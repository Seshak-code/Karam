* qa4: 1000 dense PWL steps 1 ps apart
V1 1 0 PWL(0 0 1p 0 1p 1 2p 1 2p 0 3p 0 3p 1 4p 1 4p 0 5p 0 5p 1 6p 1 6p 0 7p 0 7p 1 8p 1 8p 0 9p 0 9p 1 10p 1 10p 0 11p 0 11p 1 12p 1 12p 0 13p 0 13p 1 14p 1 14p 0 15p 0 15p 1 16p 1 16p 0 17p 0 17p 1 18p 1 18p 0 19p 0 19p 1 20p 1 20p 0 21p 0 21p 1 22p 1 22p 0 23p 0 23p 1 24p 1 24p 0 25p 0 25p 1 26p 1 26p 0 27p 0 27p 1 28p 1 28p 0 29p 0 29p 1 30p 1 30p 0 31p 0 31p 1 32p 1 32p 0 33p 0 33p 1 34p 1 34p 0 35p 0 35p 1 36p 1 36p 0 37p 0 37p 1 38p 1 38p 0 39p 0 39p 1 40p 1 40p 0 41p 0 41p 1 42p 1 42p 0 43p 0 43p 1 44p 1 44p 0 45p 0 45p 1 46p 1 46p 0 47p 0 47p 1 48p 1 48p 0 49p 0 49p 1 50p 1 50p 0 51p 0 51p 1 52p 1 52p 0 53p 0 53p 1 54p 1 54p 0 55p 0 55p 1 56p 1 56p 0 57p 0 57p 1 58p 1 58p 0 59p 0 59p 1 60p 1 60p 0 61p 0 61p 1 62p 1 62p 0 63p 0 63p 1 64p 1 64p 0 65p 0 65p 1 66p 1 66p 0 67p 0 67p 1 68p 1 68p 0 69p 0 69p 1 70p 1 70p 0 71p 0 71p 1 72p 1 72p 0 73p 0 73p 1 74p 1 74p 0 75p 0 75p 1 76p 1 76p 0 77p 0 77p 1 78p 1 78p 0 79p 0 79p 1 80p 1 80p 0 81p 0 81p 1 82p 1 82p 0 83p 0 83p 1 84p 1 84p 0 85p 0 85p 1 86p 1 86p 0 87p 0 87p 1 88p 1 88p 0 89p 0 89p 1 90p 1 90p 0 91p 0 91p 1 92p 1 92p 0 93p 0 93p 1 94p 1 94p 0 95p 0 95p 1 96p 1 96p 0 97p 0 97p 1 98p 1 98p 0 99p 0 99p 1 100p 1 100p 0 101p 0 101p 1 102p 1 102p 0 103p 0 103p 1 104p 1 104p 0 105p 0 105p 1 106p 1 106p 0 107p 0 107p 1 108p 1 108p 0 109p 0 109p 1 110p 1 110p 0 111p 0 111p 1 112p 1 112p 0 113p 0 113p 1 114p 1 114p 0 115p 0 115p 1 116p 1 116p 0 117p 0 117p 1 118p 1 118p 0 119p 0 119p 1 120p 1 120p 0 121p 0 121p 1 122p 1 122p 0 123p 0 123p 1 124p 1 124p 0 125p 0 125p 1 126p 1 126p 0 127p 0 127p 1 128p 1 128p 0 129p 0 129p 1 130p 1 130p 0 131p 0 131p 1 132p 1 132p 0 133p 0 133p 1 134p 1 134p 0 135p 0 135p 1 136p 1 136p 0 137p 0 137p 1 138p 1 138p 0 139p 0 139p 1 140p 1 140p 0 141p 0 141p 1 142p 1 142p 0 143p 0 143p 1 144p 1 144p 0 145p 0 145p 1 146p 1 146p 0 147p 0 147p 1 148p 1 148p 0 149p 0 149p 1 150p 1 150p 0 151p 0 151p 1 152p 1 152p 0 153p 0 153p 1 154p 1 154p 0 155p 0 155p 1 156p 1 156p 0 157p 0 157p 1 158p 1 158p 0 159p 0 159p 1 160p 1 160p 0 161p 0 161p 1 162p 1 162p 0 163p 0 163p 1 164p 1 164p 0 165p 0 165p 1 166p 1 166p 0 167p 0 167p 1 168p 1 168p 0 169p 0 169p 1 170p 1 170p 0 171p 0 171p 1 172p 1 172p 0 173p 0 173p 1 174p 1 174p 0 175p 0 175p 1 176p 1 176p 0 177p 0 177p 1 178p 1 178p 0 179p 0 179p 1 180p 1 180p 0 181p 0 181p 1 182p 1 182p 0 183p 0 183p 1 184p 1 184p 0 185p 0 185p 1 186p 1 186p 0 187p 0 187p 1 188p 1 188p 0 189p 0 189p 1 190p 1 190p 0 191p 0 191p 1 192p 1 192p 0 193p 0 193p 1 194p 1 194p 0 195p 0 195p 1 196p 1 196p 0 197p 0 197p 1 198p 1 198p 0 199p 0 199p 1 200p 1 200p 0 201p 0 201p 1 202p 1 202p 0 203p 0 203p 1 204p 1 204p 0 205p 0 205p 1 206p 1 206p 0 207p 0 207p 1 208p 1 208p 0 209p 0 209p 1 210p 1 210p 0 211p 0 211p 1 212p 1 212p 0 213p 0 213p 1 214p 1 214p 0 215p 0 215p 1 216p 1 216p 0 217p 0 217p 1 218p 1 218p 0 219p 0 219p 1 220p 1 220p 0 221p 0 221p 1 222p 1 222p 0 223p 0 223p 1 224p 1 224p 0 225p 0 225p 1 226p 1 226p 0 227p 0 227p 1 228p 1 228p 0 229p 0 229p 1 230p 1 230p 0 231p 0 231p 1 232p 1 232p 0 233p 0 233p 1 234p 1 234p 0 235p 0 235p 1 236p 1 236p 0 237p 0 237p 1 238p 1 238p 0 239p 0 239p 1 240p 1 240p 0 241p 0 241p 1 242p 1 242p 0 243p 0 243p 1 244p 1 244p 0 245p 0 245p 1 246p 1 246p 0 247p 0 247p 1 248p 1 248p 0 249p 0 249p 1 250p 1 250p 0 251p 0 251p 1 252p 1 252p 0 253p 0 253p 1 254p 1 254p 0 255p 0 255p 1 256p 1 256p 0 257p 0 257p 1 258p 1 258p 0 259p 0 259p 1 260p 1 260p 0 261p 0 261p 1 262p 1 262p 0 263p 0 263p 1 264p 1 264p 0 265p 0 265p 1 266p 1 266p 0 267p 0 267p 1 268p 1 268p 0 269p 0 269p 1 270p 1 270p 0 271p 0 271p 1 272p 1 272p 0 273p 0 273p 1 274p 1 274p 0 275p 0 275p 1 276p 1 276p 0 277p 0 277p 1 278p 1 278p 0 279p 0 279p 1 280p 1 280p 0 281p 0 281p 1 282p 1 282p 0 283p 0 283p 1 284p 1 284p 0 285p 0 285p 1 286p 1 286p 0 287p 0 287p 1 288p 1 288p 0 289p 0 289p 1 290p 1 290p 0 291p 0 291p 1 292p 1 292p 0 293p 0 293p 1 294p 1 294p 0 295p 0 295p 1 296p 1 296p 0 297p 0 297p 1 298p 1 298p 0 299p 0 299p 1 300p 1 300p 0 301p 0 301p 1 302p 1 302p 0 303p 0 303p 1 304p 1 304p 0 305p 0 305p 1 306p 1 306p 0 307p 0 307p 1 308p 1 308p 0 309p 0 309p 1 310p 1 310p 0 311p 0 311p 1 312p 1 312p 0 313p 0 313p 1 314p 1 314p 0 315p 0 315p 1 316p 1 316p 0 317p 0 317p 1 318p 1 318p 0 319p 0 319p 1 320p 1 320p 0 321p 0 321p 1 322p 1 322p 0 323p 0 323p 1 324p 1 324p 0 325p 0 325p 1 326p 1 326p 0 327p 0 327p 1 328p 1 328p 0 329p 0 329p 1 330p 1 330p 0 331p 0 331p 1 332p 1 332p 0 333p 0 333p 1 334p 1 334p 0 335p 0 335p 1 336p 1 336p 0 337p 0 337p 1 338p 1 338p 0 339p 0 339p 1 340p 1 340p 0 341p 0 341p 1 342p 1 342p 0 343p 0 343p 1 344p 1 344p 0 345p 0 345p 1 346p 1 346p 0 347p 0 347p 1 348p 1 348p 0 349p 0 349p 1 350p 1 350p 0 351p 0 351p 1 352p 1 352p 0 353p 0 353p 1 354p 1 354p 0 355p 0 355p 1 356p 1 356p 0 357p 0 357p 1 358p 1 358p 0 359p 0 359p 1 360p 1 360p 0 361p 0 361p 1 362p 1 362p 0 363p 0 363p 1 364p 1 364p 0 365p 0 365p 1 366p 1 366p 0 367p 0 367p 1 368p 1 368p 0 369p 0 369p 1 370p 1 370p 0 371p 0 371p 1 372p 1 372p 0 373p 0 373p 1 374p 1 374p 0 375p 0 375p 1 376p 1 376p 0 377p 0 377p 1 378p 1 378p 0 379p 0 379p 1 380p 1 380p 0 381p 0 381p 1 382p 1 382p 0 383p 0 383p 1 384p 1 384p 0 385p 0 385p 1 386p 1 386p 0 387p 0 387p 1 388p 1 388p 0 389p 0 389p 1 390p 1 390p 0 391p 0 391p 1 392p 1 392p 0 393p 0 393p 1 394p 1 394p 0 395p 0 395p 1 396p 1 396p 0 397p 0 397p 1 398p 1 398p 0 399p 0 399p 1 400p 1 400p 0 401p 0 401p 1 402p 1 402p 0 403p 0 403p 1 404p 1 404p 0 405p 0 405p 1 406p 1 406p 0 407p 0 407p 1 408p 1 408p 0 409p 0 409p 1 410p 1 410p 0 411p 0 411p 1 412p 1 412p 0 413p 0 413p 1 414p 1 414p 0 415p 0 415p 1 416p 1 416p 0 417p 0 417p 1 418p 1 418p 0 419p 0 419p 1 420p 1 420p 0 421p 0 421p 1 422p 1 422p 0 423p 0 423p 1 424p 1 424p 0 425p 0 425p 1 426p 1 426p 0 427p 0 427p 1 428p 1 428p 0 429p 0 429p 1 430p 1 430p 0 431p 0 431p 1 432p 1 432p 0 433p 0 433p 1 434p 1 434p 0 435p 0 435p 1 436p 1 436p 0 437p 0 437p 1 438p 1 438p 0 439p 0 439p 1 440p 1 440p 0 441p 0 441p 1 442p 1 442p 0 443p 0 443p 1 444p 1 444p 0 445p 0 445p 1 446p 1 446p 0 447p 0 447p 1 448p 1 448p 0 449p 0 449p 1 450p 1 450p 0 451p 0 451p 1 452p 1 452p 0 453p 0 453p 1 454p 1 454p 0 455p 0 455p 1 456p 1 456p 0 457p 0 457p 1 458p 1 458p 0 459p 0 459p 1 460p 1 460p 0 461p 0 461p 1 462p 1 462p 0 463p 0 463p 1 464p 1 464p 0 465p 0 465p 1 466p 1 466p 0 467p 0 467p 1 468p 1 468p 0 469p 0 469p 1 470p 1 470p 0 471p 0 471p 1 472p 1 472p 0 473p 0 473p 1 474p 1 474p 0 475p 0 475p 1 476p 1 476p 0 477p 0 477p 1 478p 1 478p 0 479p 0 479p 1 480p 1 480p 0 481p 0 481p 1 482p 1 482p 0 483p 0 483p 1 484p 1 484p 0 485p 0 485p 1 486p 1 486p 0 487p 0 487p 1 488p 1 488p 0 489p 0 489p 1 490p 1 490p 0 491p 0 491p 1 492p 1 492p 0 493p 0 493p 1 494p 1 494p 0 495p 0 495p 1 496p 1 496p 0 497p 0 497p 1 498p 1 498p 0 499p 0 499p 1 500p 1 500p 0 501p 0 501p 1 502p 1 502p 0 503p 0 503p 1 504p 1 504p 0 505p 0 505p 1 506p 1 506p 0 507p 0 507p 1 508p 1 508p 0 509p 0 509p 1 510p 1 510p 0 511p 0 511p 1 512p 1 512p 0 513p 0 513p 1 514p 1 514p 0 515p 0 515p 1 516p 1 516p 0 517p 0 517p 1 518p 1 518p 0 519p 0 519p 1 520p 1 520p 0 521p 0 521p 1 522p 1 522p 0 523p 0 523p 1 524p 1 524p 0 525p 0 525p 1 526p 1 526p 0 527p 0 527p 1 528p 1 528p 0 529p 0 529p 1 530p 1 530p 0 531p 0 531p 1 532p 1 532p 0 533p 0 533p 1 534p 1 534p 0 535p 0 535p 1 536p 1 536p 0 537p 0 537p 1 538p 1 538p 0 539p 0 539p 1 540p 1 540p 0 541p 0 541p 1 542p 1 542p 0 543p 0 543p 1 544p 1 544p 0 545p 0 545p 1 546p 1 546p 0 547p 0 547p 1 548p 1 548p 0 549p 0 549p 1 550p 1 550p 0 551p 0 551p 1 552p 1 552p 0 553p 0 553p 1 554p 1 554p 0 555p 0 555p 1 556p 1 556p 0 557p 0 557p 1 558p 1 558p 0 559p 0 559p 1 560p 1 560p 0 561p 0 561p 1 562p 1 562p 0 563p 0 563p 1 564p 1 564p 0 565p 0 565p 1 566p 1 566p 0 567p 0 567p 1 568p 1 568p 0 569p 0 569p 1 570p 1 570p 0 571p 0 571p 1 572p 1 572p 0 573p 0 573p 1 574p 1 574p 0 575p 0 575p 1 576p 1 576p 0 577p 0 577p 1 578p 1 578p 0 579p 0 579p 1 580p 1 580p 0 581p 0 581p 1 582p 1 582p 0 583p 0 583p 1 584p 1 584p 0 585p 0 585p 1 586p 1 586p 0 587p 0 587p 1 588p 1 588p 0 589p 0 589p 1 590p 1 590p 0 591p 0 591p 1 592p 1 592p 0 593p 0 593p 1 594p 1 594p 0 595p 0 595p 1 596p 1 596p 0 597p 0 597p 1 598p 1 598p 0 599p 0 599p 1 600p 1 600p 0 601p 0 601p 1 602p 1 602p 0 603p 0 603p 1 604p 1 604p 0 605p 0 605p 1 606p 1 606p 0 607p 0 607p 1 608p 1 608p 0 609p 0 609p 1 610p 1 610p 0 611p 0 611p 1 612p 1 612p 0 613p 0 613p 1 614p 1 614p 0 615p 0 615p 1 616p 1 616p 0 617p 0 617p 1 618p 1 618p 0 619p 0 619p 1 620p 1 620p 0 621p 0 621p 1 622p 1 622p 0 623p 0 623p 1 624p 1 624p 0 625p 0 625p 1 626p 1 626p 0 627p 0 627p 1 628p 1 628p 0 629p 0 629p 1 630p 1 630p 0 631p 0 631p 1 632p 1 632p 0 633p 0 633p 1 634p 1 634p 0 635p 0 635p 1 636p 1 636p 0 637p 0 637p 1 638p 1 638p 0 639p 0 639p 1 640p 1 640p 0 641p 0 641p 1 642p 1 642p 0 643p 0 643p 1 644p 1 644p 0 645p 0 645p 1 646p 1 646p 0 647p 0 647p 1 648p 1 648p 0 649p 0 649p 1 650p 1 650p 0 651p 0 651p 1 652p 1 652p 0 653p 0 653p 1 654p 1 654p 0 655p 0 655p 1 656p 1 656p 0 657p 0 657p 1 658p 1 658p 0 659p 0 659p 1 660p 1 660p 0 661p 0 661p 1 662p 1 662p 0 663p 0 663p 1 664p 1 664p 0 665p 0 665p 1 666p 1 666p 0 667p 0 667p 1 668p 1 668p 0 669p 0 669p 1 670p 1 670p 0 671p 0 671p 1 672p 1 672p 0 673p 0 673p 1 674p 1 674p 0 675p 0 675p 1 676p 1 676p 0 677p 0 677p 1 678p 1 678p 0 679p 0 679p 1 680p 1 680p 0 681p 0 681p 1 682p 1 682p 0 683p 0 683p 1 684p 1 684p 0 685p 0 685p 1 686p 1 686p 0 687p 0 687p 1 688p 1 688p 0 689p 0 689p 1 690p 1 690p 0 691p 0 691p 1 692p 1 692p 0 693p 0 693p 1 694p 1 694p 0 695p 0 695p 1 696p 1 696p 0 697p 0 697p 1 698p 1 698p 0 699p 0 699p 1 700p 1 700p 0 701p 0 701p 1 702p 1 702p 0 703p 0 703p 1 704p 1 704p 0 705p 0 705p 1 706p 1 706p 0 707p 0 707p 1 708p 1 708p 0 709p 0 709p 1 710p 1 710p 0 711p 0 711p 1 712p 1 712p 0 713p 0 713p 1 714p 1 714p 0 715p 0 715p 1 716p 1 716p 0 717p 0 717p 1 718p 1 718p 0 719p 0 719p 1 720p 1 720p 0 721p 0 721p 1 722p 1 722p 0 723p 0 723p 1 724p 1 724p 0 725p 0 725p 1 726p 1 726p 0 727p 0 727p 1 728p 1 728p 0 729p 0 729p 1 730p 1 730p 0 731p 0 731p 1 732p 1 732p 0 733p 0 733p 1 734p 1 734p 0 735p 0 735p 1 736p 1 736p 0 737p 0 737p 1 738p 1 738p 0 739p 0 739p 1 740p 1 740p 0 741p 0 741p 1 742p 1 742p 0 743p 0 743p 1 744p 1 744p 0 745p 0 745p 1 746p 1 746p 0 747p 0 747p 1 748p 1 748p 0 749p 0 749p 1 750p 1 750p 0 751p 0 751p 1 752p 1 752p 0 753p 0 753p 1 754p 1 754p 0 755p 0 755p 1 756p 1 756p 0 757p 0 757p 1 758p 1 758p 0 759p 0 759p 1 760p 1 760p 0 761p 0 761p 1 762p 1 762p 0 763p 0 763p 1 764p 1 764p 0 765p 0 765p 1 766p 1 766p 0 767p 0 767p 1 768p 1 768p 0 769p 0 769p 1 770p 1 770p 0 771p 0 771p 1 772p 1 772p 0 773p 0 773p 1 774p 1 774p 0 775p 0 775p 1 776p 1 776p 0 777p 0 777p 1 778p 1 778p 0 779p 0 779p 1 780p 1 780p 0 781p 0 781p 1 782p 1 782p 0 783p 0 783p 1 784p 1 784p 0 785p 0 785p 1 786p 1 786p 0 787p 0 787p 1 788p 1 788p 0 789p 0 789p 1 790p 1 790p 0 791p 0 791p 1 792p 1 792p 0 793p 0 793p 1 794p 1 794p 0 795p 0 795p 1 796p 1 796p 0 797p 0 797p 1 798p 1 798p 0 799p 0 799p 1 800p 1 800p 0 801p 0 801p 1 802p 1 802p 0 803p 0 803p 1 804p 1 804p 0 805p 0 805p 1 806p 1 806p 0 807p 0 807p 1 808p 1 808p 0 809p 0 809p 1 810p 1 810p 0 811p 0 811p 1 812p 1 812p 0 813p 0 813p 1 814p 1 814p 0 815p 0 815p 1 816p 1 816p 0 817p 0 817p 1 818p 1 818p 0 819p 0 819p 1 820p 1 820p 0 821p 0 821p 1 822p 1 822p 0 823p 0 823p 1 824p 1 824p 0 825p 0 825p 1 826p 1 826p 0 827p 0 827p 1 828p 1 828p 0 829p 0 829p 1 830p 1 830p 0 831p 0 831p 1 832p 1 832p 0 833p 0 833p 1 834p 1 834p 0 835p 0 835p 1 836p 1 836p 0 837p 0 837p 1 838p 1 838p 0 839p 0 839p 1 840p 1 840p 0 841p 0 841p 1 842p 1 842p 0 843p 0 843p 1 844p 1 844p 0 845p 0 845p 1 846p 1 846p 0 847p 0 847p 1 848p 1 848p 0 849p 0 849p 1 850p 1 850p 0 851p 0 851p 1 852p 1 852p 0 853p 0 853p 1 854p 1 854p 0 855p 0 855p 1 856p 1 856p 0 857p 0 857p 1 858p 1 858p 0 859p 0 859p 1 860p 1 860p 0 861p 0 861p 1 862p 1 862p 0 863p 0 863p 1 864p 1 864p 0 865p 0 865p 1 866p 1 866p 0 867p 0 867p 1 868p 1 868p 0 869p 0 869p 1 870p 1 870p 0 871p 0 871p 1 872p 1 872p 0 873p 0 873p 1 874p 1 874p 0 875p 0 875p 1 876p 1 876p 0 877p 0 877p 1 878p 1 878p 0 879p 0 879p 1 880p 1 880p 0 881p 0 881p 1 882p 1 882p 0 883p 0 883p 1 884p 1 884p 0 885p 0 885p 1 886p 1 886p 0 887p 0 887p 1 888p 1 888p 0 889p 0 889p 1 890p 1 890p 0 891p 0 891p 1 892p 1 892p 0 893p 0 893p 1 894p 1 894p 0 895p 0 895p 1 896p 1 896p 0 897p 0 897p 1 898p 1 898p 0 899p 0 899p 1 900p 1 900p 0 901p 0 901p 1 902p 1 902p 0 903p 0 903p 1 904p 1 904p 0 905p 0 905p 1 906p 1 906p 0 907p 0 907p 1 908p 1 908p 0 909p 0 909p 1 910p 1 910p 0 911p 0 911p 1 912p 1 912p 0 913p 0 913p 1 914p 1 914p 0 915p 0 915p 1 916p 1 916p 0 917p 0 917p 1 918p 1 918p 0 919p 0 919p 1 920p 1 920p 0 921p 0 921p 1 922p 1 922p 0 923p 0 923p 1 924p 1 924p 0 925p 0 925p 1 926p 1 926p 0 927p 0 927p 1 928p 1 928p 0 929p 0 929p 1 930p 1 930p 0 931p 0 931p 1 932p 1 932p 0 933p 0 933p 1 934p 1 934p 0 935p 0 935p 1 936p 1 936p 0 937p 0 937p 1 938p 1 938p 0 939p 0 939p 1 940p 1 940p 0 941p 0 941p 1 942p 1 942p 0 943p 0 943p 1 944p 1 944p 0 945p 0 945p 1 946p 1 946p 0 947p 0 947p 1 948p 1 948p 0 949p 0 949p 1 950p 1 950p 0 951p 0 951p 1 952p 1 952p 0 953p 0 953p 1 954p 1 954p 0 955p 0 955p 1 956p 1 956p 0 957p 0 957p 1 958p 1 958p 0 959p 0 959p 1 960p 1 960p 0 961p 0 961p 1 962p 1 962p 0 963p 0 963p 1 964p 1 964p 0 965p 0 965p 1 966p 1 966p 0 967p 0 967p 1 968p 1 968p 0 969p 0 969p 1 970p 1 970p 0 971p 0 971p 1 972p 1 972p 0 973p 0 973p 1 974p 1 974p 0 975p 0 975p 1 976p 1 976p 0 977p 0 977p 1 978p 1 978p 0 979p 0 979p 1 980p 1 980p 0 981p 0 981p 1 982p 1 982p 0 983p 0 983p 1 984p 1 984p 0 985p 0 985p 1 986p 1 986p 0 987p 0 987p 1 988p 1 988p 0 989p 0 989p 1 990p 1 990p 0 991p 0 991p 1 992p 1 992p 0 993p 0 993p 1 994p 1 994p 0 995p 0 995p 1 996p 1 996p 0 997p 0 997p 1 998p 1 998p 0 999p 0 999p 1 1000p 1 1000p 0)
R1 1 0 1k
.tran 1p 1005p
.end
