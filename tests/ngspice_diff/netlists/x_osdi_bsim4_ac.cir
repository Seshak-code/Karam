* OSDI: BSIM4 common-source amplifier, small-signal response (reactive Jacobian)
.osdi bsim4.osdi
VDD 1 0 DC 1.2
VIN 4 0 DC 0 AC 1
VB 5 0 DC 0.5
RS 4 2 10k
RB 5 2 1meg
RD 1 3 10k
N1 3 2 0 0 nch
.model nch bsim4va type=1 w=2u l=100n
.ac dec 10 1k 100g
.end
