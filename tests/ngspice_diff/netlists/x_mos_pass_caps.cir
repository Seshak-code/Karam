* MOS1 caps: NMOS pass gate charging and discharging a node (Vds changes sign, reversed Meyer)
VG 2 0 PULSE(0 5 0.5n 0.1n 0.1n 6n 20n)
VIN 1 0 PULSE(0 3 3n 0.2n 0.2n 6n 20n)
M1 1 2 3 0 NM W=10u L=1u AD=20p AS=20p
CL 3 0 50f
.model NM NMOS(VTO=0.7 KP=50u GAMMA=0.5 TOX=25n CGSO=2e-10 CGDO=2e-10 CBD=5f CBS=5f MJ=0.4)
.tran 0.02n 12n
.end
