* LEVEL=3 must error clearly
V1 1 0 DC 1
M1 1 1 0 0 NM W=10u L=1u
.model NM NMOS(LEVEL=3 VTO=0.7 KP=60u)
.op
.end
