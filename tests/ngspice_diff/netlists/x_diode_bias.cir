diode bias
V1 1 0 DC 5
R1 1 2 1k
D1 2 0 DM
.model DM D(IS=1e-14 N=1)
.op
.end
