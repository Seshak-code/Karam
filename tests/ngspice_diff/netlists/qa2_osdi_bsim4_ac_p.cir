* bsim4 PMOS ac
.osdi bsim4.osdi
VDD 1 0 DC 1.2
VG 2 0 DC 0.5 AC 1
RD 3 0 5k
N1 3 2 1 1 pch
.model pch bsim4va type=-1 w=2u l=100n
.ac dec 5 1k 100g
.end
