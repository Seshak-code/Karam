* QA: PMOS pass gate with caps — Vds changes sign, charge injection through CGSO/CGDO
VIN 1 0 SIN(0 2.5 1k)
VGP 4 0 DC -5
VNN 5 0 DC -5
RL 3 0 10k
CL 3 0 1n
MP 1 4 3 5 PM W=20u L=1u
.model PM PMOS(KP=100u VTO=-0.7 GAMMA=0.4 PHI=0.6 TOX=40n CGSO=2n CGDO=2n CGBO=1n CBD=20f CBS=20f)
.tran 5u 3m
.end
