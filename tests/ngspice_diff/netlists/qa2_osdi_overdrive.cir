* bsim4 at 5 V, far beyond rating
.osdi bsim4.osdi
VDD 1 0 DC 5
VG 2 0 DC 5
R1 1 3 100
N1 3 2 0 0 nch
.model nch bsim4va type=1 w=10u l=100n
.dc VG 0 5 0.5
.end
