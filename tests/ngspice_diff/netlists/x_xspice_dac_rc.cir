* XSPICE Reference 5: RC load driven by dac_bridge
vin in_a 0 pulse(0 3 1n 0.1n 0.1n 5n 10n)
a_adc [in_a] [clk_d] adc_mod
.model adc_mod adc_bridge(in_low=1.0 in_high=2.0)

a_dac [clk_d] [v_dac] dac_mod
.model dac_mod dac_bridge(out_low=0 out_high=3.3 t_rise=1n t_fall=1n)

R1 v_dac v_out 500
C1 v_out 0 10p

.tran 0.1n 25n
.control
run
print v(v_dac) v(v_out)
eprint clk_d
.endc
.end
