* qa3 BUG-4: sky130 nfet nf=2 with W=1.26 exactly on a bin edge (engine 2.31e-5 vs ngspice 3.33e-5 A before)
.lib lib/sky130_tt_min.lib tt
VDD 1 0 DC 1.8
VG 2 0 DC 0.9
RD 1 3 1k
XM 3 2 0 0 sky130_fd_pr__nfet_01v8 l=0.15 w=1.26 nf=2
.op
.end
