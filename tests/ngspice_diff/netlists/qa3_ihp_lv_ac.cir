* qa3: IHP lv nmos CS stage ac (m=4, ng=2)
.osdi psp103.osdi
.lib pdk/ihp/ihp-sg13g2/libs.tech/ngspice/models/cornerMOSlv.lib mos_tt
VDD 1 0 DC 1.2
VG 2 0 DC 0.55 AC 1
RD 1 3 2k
XN 3 2 0 0 sg13_lv_nmos w=2u l=0.13u ng=2 m=4
CL 3 0 50f
.ac dec 10 1meg 100g
.end
