* MOS1 caps: common-source amplifier frequency response (Miller CGD, junction caps)
VDD 1 0 DC 5
VIN 4 0 DC 0 AC 1
RS 4 2 10k
VB 5 0 DC 1.2
RB 5 2 1meg
RD 1 3 10k
M1 3 2 0 0 NM W=20u L=1u AD=40p AS=40p PD=24u PS=24u
.model NM NMOS(VTO=0.7 KP=50u LAMBDA=0.02 TOX=20n CGSO=4e-10 CGDO=4e-10 CGBO=2e-10 CJ=3e-4 CJSW=5e-10)
.ac dec 10 1k 10g
.end
