* bsimcmg ac
.osdi bsimcmg.osdi
VDD 1 0 DC 0.8
VG 2 0 DC 0.5 AC 1
RD 1 3 5k
N1 3 2 0 0 nfin
.model nfin bsimcmg_va type=1
.ac dec 5 1k 100g
.end
