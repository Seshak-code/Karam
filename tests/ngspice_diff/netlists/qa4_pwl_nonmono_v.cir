* qa4: PWL voltage source with non-monotonic decreasing time points
V1 1 0 PWL(0 0 2n 1 1n 0 3n 0)
R1 1 0 1k
.tran 0.1n 3n
.end
