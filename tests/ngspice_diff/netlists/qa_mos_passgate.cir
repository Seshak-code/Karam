* QA: NMOS pass gate, Vds changes sign during the transient (S/D exchange on the fly)
VIN 1 0 SIN(0 2.5 1k)
VG 2 0 DC 5
RL 3 0 10k
CL 3 0 10n
M1 1 2 3 0 NM W=10u L=1u
.model NM NMOS(KP=100u VTO=0.7 GAMMA=0.4 PHI=0.6)
.tran 5u 3m
.end
