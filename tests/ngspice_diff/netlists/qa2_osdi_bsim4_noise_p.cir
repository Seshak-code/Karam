* bsim4 PMOS noise
.osdi bsim4.osdi
VDD 1 0 DC 1.2
VG 2 0 DC 0.5 AC 1
RD 3 0 5k
N1 3 2 1 1 pch
.model pch bsim4va type=-1 w=2u l=100n
.noise v(3) VG dec 5 1 10g
.end
