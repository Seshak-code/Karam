* CE amplifier .ac: CJE, CJC split by XCJC around RB, TF with XTF/VTF/ITF, TR, CJS (substrate)
VCC 1 0 DC 12
VIN 6 0 DC 0 AC 1
CIN 6 2 1u
R1 1 2 47k
R2 2 0 10k
RC 1 3 4.7k
Q1 3 2 4 0 QAC
RE 4 0 1k
CE 4 0 100u
.model QAC NPN(IS=1e-15 BF=200 VAF=80 RB=150 RC=20 RE=1 CJE=2p VJE=0.8 MJE=0.35 CJC=1p VJC=0.6 MJC=0.4 XCJC=0.4 TF=400p XTF=3 VTF=4 ITF=10m TR=20n CJS=1.5p VJS=0.7 MJS=0.3)
.ac dec 10 100 10G
.end
