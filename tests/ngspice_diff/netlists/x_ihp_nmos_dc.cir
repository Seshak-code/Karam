* IHP SG13G2 (real PDK): lv NMOS through the PDK's own subcircuit, PSP103 via OSDI, tt corner
.osdi psp103.osdi
.lib pdk/ihp/ihp-sg13g2/libs.tech/ngspice/models/cornerMOSlv.lib mos_tt
VDD 1 0 DC 1.2
VG 2 0 DC 0
RD 1 3 10k
XN 3 2 0 0 sg13_lv_nmos w=1u l=0.13u
.dc VG 0 1.2 0.05
.end
