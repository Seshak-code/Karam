* QA netlist
V1 1 0 DC 1
D1 1 0 DX
.model DX D(IS=1e-14 TNOM=50 XTI=3 EG=1.1 KF=1e-16 AF=1 JSW=1e-12 CJSW=1p)
.op
.end
