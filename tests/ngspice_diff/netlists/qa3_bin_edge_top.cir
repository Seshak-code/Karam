* qa3 BUG: W exactly at WMAX / L exactly at LMAX of the last bin: ngspice uses the last bin, engine "no bin covers"
.model nb.0 nmos (level=54 version=4.5 vth0=0.40 toxe=4n toxm=4n lmin=1u lmax=10u wmin=1u wmax=20u)
V1 1 0 DC 2
VG 2 0 DC 0.7
M1 3 2 0 0 nb W=20u L=2u
R1 1 3 10k
.op
.end
