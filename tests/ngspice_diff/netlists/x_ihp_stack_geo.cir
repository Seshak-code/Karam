* IHP SG13G2: two lv NMOS in series (one specialized block, two instances), DC
.osdi psp103.osdi
.lib pdk/ihp/ihp-sg13g2/libs.tech/ngspice/models/cornerMOSlv.lib mos_tt
VDD 1 0 DC 1.2
VG 2 0 DC 0
RD 1 3 10k
XN0 3 2 4 0 sg13_lv_nmos w=740.00n l=130.00n ng=1 ad=2.516e-13 as=2.516e-13 pd=2.16e-06 ps=2.16e-06 m=1
XN1 4 2 0 0 sg13_lv_nmos w=740.00n l=130.00n ng=1 ad=2.516e-13 as=2.516e-13 pd=2.16e-06 ps=2.16e-06 m=1
.dc VG 0 1.2 0.05
.end
