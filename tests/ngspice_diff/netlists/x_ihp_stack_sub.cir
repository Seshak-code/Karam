* IHP SG13G2: the series NMOS stack inside a subcircuit (internal stack node local to the cell)
.osdi psp103.osdi
.lib pdk/ihp/ihp-sg13g2/libs.tech/ngspice/models/cornerMOSlv.lib mos_tt
.subckt stack y a vss
XN0 y a mid vss sg13_lv_nmos w=740.00n l=130.00n ng=1 ad=2.516e-13 as=2.516e-13 pd=2.16e-06 ps=2.16e-06 m=1
XN1 mid a vss vss sg13_lv_nmos w=740.00n l=130.00n ng=1 ad=2.516e-13 as=2.516e-13 pd=2.16e-06 ps=2.16e-06 m=1
.ends
VDD 1 0 DC 1.2
VG 2 0 DC 0
RD 1 3 10k
X1 3 2 0 stack
.dc VG 0 1.2 0.05
.end
