* Series stack inside a subcircuit, each transistor itself a subcircuit (two instances of one
* block inside another block): built-in MOS1
.model nm nmos (vto=0.5 kp=200u lambda=0.05)
.subckt nfet d g s b
M1 d g s b nm W=1u L=0.13u
.ends
.subckt stack y a vss
XN0 y a mid vss nfet
XN1 mid a vss vss nfet
.ends
VDD 1 0 DC 1.2
VG 2 0 DC 0
RD 1 3 10k
X1 3 2 0 stack
.dc VG 0 1.2 0.05
.end
