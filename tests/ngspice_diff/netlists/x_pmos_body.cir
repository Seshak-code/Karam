* MOS1: PMOS source follower, body at VDD (body effect, PMOS polarity)
VDD 1 0 DC 5
VG 2 0 DC 5
RS 1 3 10k
M1 0 2 3 1 PM W=40u L=1u
.model PM PMOS(KP=40u VTO=-0.7 GAMMA=0.5 PHI=0.65 LAMBDA=0.03)
.dc VG 0 5 0.25
.end
