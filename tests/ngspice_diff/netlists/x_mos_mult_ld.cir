* MOS1: instance multiplier M and lateral diffusion LD
VDD 1 0 DC 3
VG 2 0 DC 0
RD 1 3 2k
M1 3 2 0 0 NM W=5u L=2u M=3
.model NM NMOS(KP=60u VTO=0.5 LAMBDA=0.01 LD=0.2u)
.dc VG 0 3 0.1
.end
