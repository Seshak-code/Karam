* QA diag: coarse tstep with plain MOS, NO caps (attributes the qa_mos_coarse failure)
VDD 1 0 DC 5
VIN 2 0 PULSE(0 5 2u 5u 5u 5u 20u)
RD 1 3 10k
CG 3 0 1n
M1 3 2 0 0 NM W=20u L=1u
.model NM NMOS(KP=100u VTO=0.7 LAMBDA=0.02)
.tran 25u 100u
.end
