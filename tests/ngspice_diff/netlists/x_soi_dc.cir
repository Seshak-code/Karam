* B4SOI (LEVEL 10) NMOS, 4 terminals (d g s e): Id-Vgs family on the OSDI bsimsoi vs ngspice native
.include lib/b4soi_nmos.inc
VD d 0 DC 1.0
VG g 0 DC 0
VE e 0 DC 0
M1 d g 0 e nmos1 w=4u l=0.15u
.dc VG 0 1.2 0.05 VD 0.1 1.1 0.5
.end
