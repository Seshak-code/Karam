* nested .include from sub directories (.end inside an included file)
V1 1 0 DC 2
R1 1 2 1k
R6 1 3 1k
.include 'lib/qa2_a.inc'
R7 1 2 {rtop}
.op
.end
