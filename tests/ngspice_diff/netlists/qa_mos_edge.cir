* QA: NMOS at the conduction edge — fine sweep across VTO (vgst -> 0), Vds ~ 0 through 1k
VG 2 0 DC 0.7
VD 1 0 DC 0
RD 1 3 1k
M1 3 2 0 0 NM W=10u L=2u
.model NM NMOS(KP=100u VTO=0.7 LAMBDA=0.02)
.dc VG 0.60 0.80 0.005
.end
