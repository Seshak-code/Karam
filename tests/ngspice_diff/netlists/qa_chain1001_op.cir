* QA: 1000-stage CMOS inverter chain .op, in=5
VDD 1 0 DC 5
VIN 2 0 DC 5
X1 2 3 1 INV
X2 3 4 1 INV
X3 4 5 1 INV
X4 5 6 1 INV
X5 6 7 1 INV
X6 7 8 1 INV
X7 8 9 1 INV
X8 9 10 1 INV
X9 10 11 1 INV
X10 11 12 1 INV
X11 12 13 1 INV
X12 13 14 1 INV
X13 14 15 1 INV
X14 15 16 1 INV
X15 16 17 1 INV
X16 17 18 1 INV
X17 18 19 1 INV
X18 19 20 1 INV
X19 20 21 1 INV
X20 21 22 1 INV
X21 22 23 1 INV
X22 23 24 1 INV
X23 24 25 1 INV
X24 25 26 1 INV
X25 26 27 1 INV
X26 27 28 1 INV
X27 28 29 1 INV
X28 29 30 1 INV
X29 30 31 1 INV
X30 31 32 1 INV
X31 32 33 1 INV
X32 33 34 1 INV
X33 34 35 1 INV
X34 35 36 1 INV
X35 36 37 1 INV
X36 37 38 1 INV
X37 38 39 1 INV
X38 39 40 1 INV
X39 40 41 1 INV
X40 41 42 1 INV
X41 42 43 1 INV
X42 43 44 1 INV
X43 44 45 1 INV
X44 45 46 1 INV
X45 46 47 1 INV
X46 47 48 1 INV
X47 48 49 1 INV
X48 49 50 1 INV
X49 50 51 1 INV
X50 51 52 1 INV
X51 52 53 1 INV
X52 53 54 1 INV
X53 54 55 1 INV
X54 55 56 1 INV
X55 56 57 1 INV
X56 57 58 1 INV
X57 58 59 1 INV
X58 59 60 1 INV
X59 60 61 1 INV
X60 61 62 1 INV
X61 62 63 1 INV
X62 63 64 1 INV
X63 64 65 1 INV
X64 65 66 1 INV
X65 66 67 1 INV
X66 67 68 1 INV
X67 68 69 1 INV
X68 69 70 1 INV
X69 70 71 1 INV
X70 71 72 1 INV
X71 72 73 1 INV
X72 73 74 1 INV
X73 74 75 1 INV
X74 75 76 1 INV
X75 76 77 1 INV
X76 77 78 1 INV
X77 78 79 1 INV
X78 79 80 1 INV
X79 80 81 1 INV
X80 81 82 1 INV
X81 82 83 1 INV
X82 83 84 1 INV
X83 84 85 1 INV
X84 85 86 1 INV
X85 86 87 1 INV
X86 87 88 1 INV
X87 88 89 1 INV
X88 89 90 1 INV
X89 90 91 1 INV
X90 91 92 1 INV
X91 92 93 1 INV
X92 93 94 1 INV
X93 94 95 1 INV
X94 95 96 1 INV
X95 96 97 1 INV
X96 97 98 1 INV
X97 98 99 1 INV
X98 99 100 1 INV
X99 100 101 1 INV
X100 101 102 1 INV
X101 102 103 1 INV
X102 103 104 1 INV
X103 104 105 1 INV
X104 105 106 1 INV
X105 106 107 1 INV
X106 107 108 1 INV
X107 108 109 1 INV
X108 109 110 1 INV
X109 110 111 1 INV
X110 111 112 1 INV
X111 112 113 1 INV
X112 113 114 1 INV
X113 114 115 1 INV
X114 115 116 1 INV
X115 116 117 1 INV
X116 117 118 1 INV
X117 118 119 1 INV
X118 119 120 1 INV
X119 120 121 1 INV
X120 121 122 1 INV
X121 122 123 1 INV
X122 123 124 1 INV
X123 124 125 1 INV
X124 125 126 1 INV
X125 126 127 1 INV
X126 127 128 1 INV
X127 128 129 1 INV
X128 129 130 1 INV
X129 130 131 1 INV
X130 131 132 1 INV
X131 132 133 1 INV
X132 133 134 1 INV
X133 134 135 1 INV
X134 135 136 1 INV
X135 136 137 1 INV
X136 137 138 1 INV
X137 138 139 1 INV
X138 139 140 1 INV
X139 140 141 1 INV
X140 141 142 1 INV
X141 142 143 1 INV
X142 143 144 1 INV
X143 144 145 1 INV
X144 145 146 1 INV
X145 146 147 1 INV
X146 147 148 1 INV
X147 148 149 1 INV
X148 149 150 1 INV
X149 150 151 1 INV
X150 151 152 1 INV
X151 152 153 1 INV
X152 153 154 1 INV
X153 154 155 1 INV
X154 155 156 1 INV
X155 156 157 1 INV
X156 157 158 1 INV
X157 158 159 1 INV
X158 159 160 1 INV
X159 160 161 1 INV
X160 161 162 1 INV
X161 162 163 1 INV
X162 163 164 1 INV
X163 164 165 1 INV
X164 165 166 1 INV
X165 166 167 1 INV
X166 167 168 1 INV
X167 168 169 1 INV
X168 169 170 1 INV
X169 170 171 1 INV
X170 171 172 1 INV
X171 172 173 1 INV
X172 173 174 1 INV
X173 174 175 1 INV
X174 175 176 1 INV
X175 176 177 1 INV
X176 177 178 1 INV
X177 178 179 1 INV
X178 179 180 1 INV
X179 180 181 1 INV
X180 181 182 1 INV
X181 182 183 1 INV
X182 183 184 1 INV
X183 184 185 1 INV
X184 185 186 1 INV
X185 186 187 1 INV
X186 187 188 1 INV
X187 188 189 1 INV
X188 189 190 1 INV
X189 190 191 1 INV
X190 191 192 1 INV
X191 192 193 1 INV
X192 193 194 1 INV
X193 194 195 1 INV
X194 195 196 1 INV
X195 196 197 1 INV
X196 197 198 1 INV
X197 198 199 1 INV
X198 199 200 1 INV
X199 200 201 1 INV
X200 201 202 1 INV
X201 202 203 1 INV
X202 203 204 1 INV
X203 204 205 1 INV
X204 205 206 1 INV
X205 206 207 1 INV
X206 207 208 1 INV
X207 208 209 1 INV
X208 209 210 1 INV
X209 210 211 1 INV
X210 211 212 1 INV
X211 212 213 1 INV
X212 213 214 1 INV
X213 214 215 1 INV
X214 215 216 1 INV
X215 216 217 1 INV
X216 217 218 1 INV
X217 218 219 1 INV
X218 219 220 1 INV
X219 220 221 1 INV
X220 221 222 1 INV
X221 222 223 1 INV
X222 223 224 1 INV
X223 224 225 1 INV
X224 225 226 1 INV
X225 226 227 1 INV
X226 227 228 1 INV
X227 228 229 1 INV
X228 229 230 1 INV
X229 230 231 1 INV
X230 231 232 1 INV
X231 232 233 1 INV
X232 233 234 1 INV
X233 234 235 1 INV
X234 235 236 1 INV
X235 236 237 1 INV
X236 237 238 1 INV
X237 238 239 1 INV
X238 239 240 1 INV
X239 240 241 1 INV
X240 241 242 1 INV
X241 242 243 1 INV
X242 243 244 1 INV
X243 244 245 1 INV
X244 245 246 1 INV
X245 246 247 1 INV
X246 247 248 1 INV
X247 248 249 1 INV
X248 249 250 1 INV
X249 250 251 1 INV
X250 251 252 1 INV
X251 252 253 1 INV
X252 253 254 1 INV
X253 254 255 1 INV
X254 255 256 1 INV
X255 256 257 1 INV
X256 257 258 1 INV
X257 258 259 1 INV
X258 259 260 1 INV
X259 260 261 1 INV
X260 261 262 1 INV
X261 262 263 1 INV
X262 263 264 1 INV
X263 264 265 1 INV
X264 265 266 1 INV
X265 266 267 1 INV
X266 267 268 1 INV
X267 268 269 1 INV
X268 269 270 1 INV
X269 270 271 1 INV
X270 271 272 1 INV
X271 272 273 1 INV
X272 273 274 1 INV
X273 274 275 1 INV
X274 275 276 1 INV
X275 276 277 1 INV
X276 277 278 1 INV
X277 278 279 1 INV
X278 279 280 1 INV
X279 280 281 1 INV
X280 281 282 1 INV
X281 282 283 1 INV
X282 283 284 1 INV
X283 284 285 1 INV
X284 285 286 1 INV
X285 286 287 1 INV
X286 287 288 1 INV
X287 288 289 1 INV
X288 289 290 1 INV
X289 290 291 1 INV
X290 291 292 1 INV
X291 292 293 1 INV
X292 293 294 1 INV
X293 294 295 1 INV
X294 295 296 1 INV
X295 296 297 1 INV
X296 297 298 1 INV
X297 298 299 1 INV
X298 299 300 1 INV
X299 300 301 1 INV
X300 301 302 1 INV
X301 302 303 1 INV
X302 303 304 1 INV
X303 304 305 1 INV
X304 305 306 1 INV
X305 306 307 1 INV
X306 307 308 1 INV
X307 308 309 1 INV
X308 309 310 1 INV
X309 310 311 1 INV
X310 311 312 1 INV
X311 312 313 1 INV
X312 313 314 1 INV
X313 314 315 1 INV
X314 315 316 1 INV
X315 316 317 1 INV
X316 317 318 1 INV
X317 318 319 1 INV
X318 319 320 1 INV
X319 320 321 1 INV
X320 321 322 1 INV
X321 322 323 1 INV
X322 323 324 1 INV
X323 324 325 1 INV
X324 325 326 1 INV
X325 326 327 1 INV
X326 327 328 1 INV
X327 328 329 1 INV
X328 329 330 1 INV
X329 330 331 1 INV
X330 331 332 1 INV
X331 332 333 1 INV
X332 333 334 1 INV
X333 334 335 1 INV
X334 335 336 1 INV
X335 336 337 1 INV
X336 337 338 1 INV
X337 338 339 1 INV
X338 339 340 1 INV
X339 340 341 1 INV
X340 341 342 1 INV
X341 342 343 1 INV
X342 343 344 1 INV
X343 344 345 1 INV
X344 345 346 1 INV
X345 346 347 1 INV
X346 347 348 1 INV
X347 348 349 1 INV
X348 349 350 1 INV
X349 350 351 1 INV
X350 351 352 1 INV
X351 352 353 1 INV
X352 353 354 1 INV
X353 354 355 1 INV
X354 355 356 1 INV
X355 356 357 1 INV
X356 357 358 1 INV
X357 358 359 1 INV
X358 359 360 1 INV
X359 360 361 1 INV
X360 361 362 1 INV
X361 362 363 1 INV
X362 363 364 1 INV
X363 364 365 1 INV
X364 365 366 1 INV
X365 366 367 1 INV
X366 367 368 1 INV
X367 368 369 1 INV
X368 369 370 1 INV
X369 370 371 1 INV
X370 371 372 1 INV
X371 372 373 1 INV
X372 373 374 1 INV
X373 374 375 1 INV
X374 375 376 1 INV
X375 376 377 1 INV
X376 377 378 1 INV
X377 378 379 1 INV
X378 379 380 1 INV
X379 380 381 1 INV
X380 381 382 1 INV
X381 382 383 1 INV
X382 383 384 1 INV
X383 384 385 1 INV
X384 385 386 1 INV
X385 386 387 1 INV
X386 387 388 1 INV
X387 388 389 1 INV
X388 389 390 1 INV
X389 390 391 1 INV
X390 391 392 1 INV
X391 392 393 1 INV
X392 393 394 1 INV
X393 394 395 1 INV
X394 395 396 1 INV
X395 396 397 1 INV
X396 397 398 1 INV
X397 398 399 1 INV
X398 399 400 1 INV
X399 400 401 1 INV
X400 401 402 1 INV
X401 402 403 1 INV
X402 403 404 1 INV
X403 404 405 1 INV
X404 405 406 1 INV
X405 406 407 1 INV
X406 407 408 1 INV
X407 408 409 1 INV
X408 409 410 1 INV
X409 410 411 1 INV
X410 411 412 1 INV
X411 412 413 1 INV
X412 413 414 1 INV
X413 414 415 1 INV
X414 415 416 1 INV
X415 416 417 1 INV
X416 417 418 1 INV
X417 418 419 1 INV
X418 419 420 1 INV
X419 420 421 1 INV
X420 421 422 1 INV
X421 422 423 1 INV
X422 423 424 1 INV
X423 424 425 1 INV
X424 425 426 1 INV
X425 426 427 1 INV
X426 427 428 1 INV
X427 428 429 1 INV
X428 429 430 1 INV
X429 430 431 1 INV
X430 431 432 1 INV
X431 432 433 1 INV
X432 433 434 1 INV
X433 434 435 1 INV
X434 435 436 1 INV
X435 436 437 1 INV
X436 437 438 1 INV
X437 438 439 1 INV
X438 439 440 1 INV
X439 440 441 1 INV
X440 441 442 1 INV
X441 442 443 1 INV
X442 443 444 1 INV
X443 444 445 1 INV
X444 445 446 1 INV
X445 446 447 1 INV
X446 447 448 1 INV
X447 448 449 1 INV
X448 449 450 1 INV
X449 450 451 1 INV
X450 451 452 1 INV
X451 452 453 1 INV
X452 453 454 1 INV
X453 454 455 1 INV
X454 455 456 1 INV
X455 456 457 1 INV
X456 457 458 1 INV
X457 458 459 1 INV
X458 459 460 1 INV
X459 460 461 1 INV
X460 461 462 1 INV
X461 462 463 1 INV
X462 463 464 1 INV
X463 464 465 1 INV
X464 465 466 1 INV
X465 466 467 1 INV
X466 467 468 1 INV
X467 468 469 1 INV
X468 469 470 1 INV
X469 470 471 1 INV
X470 471 472 1 INV
X471 472 473 1 INV
X472 473 474 1 INV
X473 474 475 1 INV
X474 475 476 1 INV
X475 476 477 1 INV
X476 477 478 1 INV
X477 478 479 1 INV
X478 479 480 1 INV
X479 480 481 1 INV
X480 481 482 1 INV
X481 482 483 1 INV
X482 483 484 1 INV
X483 484 485 1 INV
X484 485 486 1 INV
X485 486 487 1 INV
X486 487 488 1 INV
X487 488 489 1 INV
X488 489 490 1 INV
X489 490 491 1 INV
X490 491 492 1 INV
X491 492 493 1 INV
X492 493 494 1 INV
X493 494 495 1 INV
X494 495 496 1 INV
X495 496 497 1 INV
X496 497 498 1 INV
X497 498 499 1 INV
X498 499 500 1 INV
X499 500 501 1 INV
X500 501 502 1 INV
X501 502 503 1 INV
X502 503 504 1 INV
X503 504 505 1 INV
X504 505 506 1 INV
X505 506 507 1 INV
X506 507 508 1 INV
X507 508 509 1 INV
X508 509 510 1 INV
X509 510 511 1 INV
X510 511 512 1 INV
X511 512 513 1 INV
X512 513 514 1 INV
X513 514 515 1 INV
X514 515 516 1 INV
X515 516 517 1 INV
X516 517 518 1 INV
X517 518 519 1 INV
X518 519 520 1 INV
X519 520 521 1 INV
X520 521 522 1 INV
X521 522 523 1 INV
X522 523 524 1 INV
X523 524 525 1 INV
X524 525 526 1 INV
X525 526 527 1 INV
X526 527 528 1 INV
X527 528 529 1 INV
X528 529 530 1 INV
X529 530 531 1 INV
X530 531 532 1 INV
X531 532 533 1 INV
X532 533 534 1 INV
X533 534 535 1 INV
X534 535 536 1 INV
X535 536 537 1 INV
X536 537 538 1 INV
X537 538 539 1 INV
X538 539 540 1 INV
X539 540 541 1 INV
X540 541 542 1 INV
X541 542 543 1 INV
X542 543 544 1 INV
X543 544 545 1 INV
X544 545 546 1 INV
X545 546 547 1 INV
X546 547 548 1 INV
X547 548 549 1 INV
X548 549 550 1 INV
X549 550 551 1 INV
X550 551 552 1 INV
X551 552 553 1 INV
X552 553 554 1 INV
X553 554 555 1 INV
X554 555 556 1 INV
X555 556 557 1 INV
X556 557 558 1 INV
X557 558 559 1 INV
X558 559 560 1 INV
X559 560 561 1 INV
X560 561 562 1 INV
X561 562 563 1 INV
X562 563 564 1 INV
X563 564 565 1 INV
X564 565 566 1 INV
X565 566 567 1 INV
X566 567 568 1 INV
X567 568 569 1 INV
X568 569 570 1 INV
X569 570 571 1 INV
X570 571 572 1 INV
X571 572 573 1 INV
X572 573 574 1 INV
X573 574 575 1 INV
X574 575 576 1 INV
X575 576 577 1 INV
X576 577 578 1 INV
X577 578 579 1 INV
X578 579 580 1 INV
X579 580 581 1 INV
X580 581 582 1 INV
X581 582 583 1 INV
X582 583 584 1 INV
X583 584 585 1 INV
X584 585 586 1 INV
X585 586 587 1 INV
X586 587 588 1 INV
X587 588 589 1 INV
X588 589 590 1 INV
X589 590 591 1 INV
X590 591 592 1 INV
X591 592 593 1 INV
X592 593 594 1 INV
X593 594 595 1 INV
X594 595 596 1 INV
X595 596 597 1 INV
X596 597 598 1 INV
X597 598 599 1 INV
X598 599 600 1 INV
X599 600 601 1 INV
X600 601 602 1 INV
X601 602 603 1 INV
X602 603 604 1 INV
X603 604 605 1 INV
X604 605 606 1 INV
X605 606 607 1 INV
X606 607 608 1 INV
X607 608 609 1 INV
X608 609 610 1 INV
X609 610 611 1 INV
X610 611 612 1 INV
X611 612 613 1 INV
X612 613 614 1 INV
X613 614 615 1 INV
X614 615 616 1 INV
X615 616 617 1 INV
X616 617 618 1 INV
X617 618 619 1 INV
X618 619 620 1 INV
X619 620 621 1 INV
X620 621 622 1 INV
X621 622 623 1 INV
X622 623 624 1 INV
X623 624 625 1 INV
X624 625 626 1 INV
X625 626 627 1 INV
X626 627 628 1 INV
X627 628 629 1 INV
X628 629 630 1 INV
X629 630 631 1 INV
X630 631 632 1 INV
X631 632 633 1 INV
X632 633 634 1 INV
X633 634 635 1 INV
X634 635 636 1 INV
X635 636 637 1 INV
X636 637 638 1 INV
X637 638 639 1 INV
X638 639 640 1 INV
X639 640 641 1 INV
X640 641 642 1 INV
X641 642 643 1 INV
X642 643 644 1 INV
X643 644 645 1 INV
X644 645 646 1 INV
X645 646 647 1 INV
X646 647 648 1 INV
X647 648 649 1 INV
X648 649 650 1 INV
X649 650 651 1 INV
X650 651 652 1 INV
X651 652 653 1 INV
X652 653 654 1 INV
X653 654 655 1 INV
X654 655 656 1 INV
X655 656 657 1 INV
X656 657 658 1 INV
X657 658 659 1 INV
X658 659 660 1 INV
X659 660 661 1 INV
X660 661 662 1 INV
X661 662 663 1 INV
X662 663 664 1 INV
X663 664 665 1 INV
X664 665 666 1 INV
X665 666 667 1 INV
X666 667 668 1 INV
X667 668 669 1 INV
X668 669 670 1 INV
X669 670 671 1 INV
X670 671 672 1 INV
X671 672 673 1 INV
X672 673 674 1 INV
X673 674 675 1 INV
X674 675 676 1 INV
X675 676 677 1 INV
X676 677 678 1 INV
X677 678 679 1 INV
X678 679 680 1 INV
X679 680 681 1 INV
X680 681 682 1 INV
X681 682 683 1 INV
X682 683 684 1 INV
X683 684 685 1 INV
X684 685 686 1 INV
X685 686 687 1 INV
X686 687 688 1 INV
X687 688 689 1 INV
X688 689 690 1 INV
X689 690 691 1 INV
X690 691 692 1 INV
X691 692 693 1 INV
X692 693 694 1 INV
X693 694 695 1 INV
X694 695 696 1 INV
X695 696 697 1 INV
X696 697 698 1 INV
X697 698 699 1 INV
X698 699 700 1 INV
X699 700 701 1 INV
X700 701 702 1 INV
X701 702 703 1 INV
X702 703 704 1 INV
X703 704 705 1 INV
X704 705 706 1 INV
X705 706 707 1 INV
X706 707 708 1 INV
X707 708 709 1 INV
X708 709 710 1 INV
X709 710 711 1 INV
X710 711 712 1 INV
X711 712 713 1 INV
X712 713 714 1 INV
X713 714 715 1 INV
X714 715 716 1 INV
X715 716 717 1 INV
X716 717 718 1 INV
X717 718 719 1 INV
X718 719 720 1 INV
X719 720 721 1 INV
X720 721 722 1 INV
X721 722 723 1 INV
X722 723 724 1 INV
X723 724 725 1 INV
X724 725 726 1 INV
X725 726 727 1 INV
X726 727 728 1 INV
X727 728 729 1 INV
X728 729 730 1 INV
X729 730 731 1 INV
X730 731 732 1 INV
X731 732 733 1 INV
X732 733 734 1 INV
X733 734 735 1 INV
X734 735 736 1 INV
X735 736 737 1 INV
X736 737 738 1 INV
X737 738 739 1 INV
X738 739 740 1 INV
X739 740 741 1 INV
X740 741 742 1 INV
X741 742 743 1 INV
X742 743 744 1 INV
X743 744 745 1 INV
X744 745 746 1 INV
X745 746 747 1 INV
X746 747 748 1 INV
X747 748 749 1 INV
X748 749 750 1 INV
X749 750 751 1 INV
X750 751 752 1 INV
X751 752 753 1 INV
X752 753 754 1 INV
X753 754 755 1 INV
X754 755 756 1 INV
X755 756 757 1 INV
X756 757 758 1 INV
X757 758 759 1 INV
X758 759 760 1 INV
X759 760 761 1 INV
X760 761 762 1 INV
X761 762 763 1 INV
X762 763 764 1 INV
X763 764 765 1 INV
X764 765 766 1 INV
X765 766 767 1 INV
X766 767 768 1 INV
X767 768 769 1 INV
X768 769 770 1 INV
X769 770 771 1 INV
X770 771 772 1 INV
X771 772 773 1 INV
X772 773 774 1 INV
X773 774 775 1 INV
X774 775 776 1 INV
X775 776 777 1 INV
X776 777 778 1 INV
X777 778 779 1 INV
X778 779 780 1 INV
X779 780 781 1 INV
X780 781 782 1 INV
X781 782 783 1 INV
X782 783 784 1 INV
X783 784 785 1 INV
X784 785 786 1 INV
X785 786 787 1 INV
X786 787 788 1 INV
X787 788 789 1 INV
X788 789 790 1 INV
X789 790 791 1 INV
X790 791 792 1 INV
X791 792 793 1 INV
X792 793 794 1 INV
X793 794 795 1 INV
X794 795 796 1 INV
X795 796 797 1 INV
X796 797 798 1 INV
X797 798 799 1 INV
X798 799 800 1 INV
X799 800 801 1 INV
X800 801 802 1 INV
X801 802 803 1 INV
X802 803 804 1 INV
X803 804 805 1 INV
X804 805 806 1 INV
X805 806 807 1 INV
X806 807 808 1 INV
X807 808 809 1 INV
X808 809 810 1 INV
X809 810 811 1 INV
X810 811 812 1 INV
X811 812 813 1 INV
X812 813 814 1 INV
X813 814 815 1 INV
X814 815 816 1 INV
X815 816 817 1 INV
X816 817 818 1 INV
X817 818 819 1 INV
X818 819 820 1 INV
X819 820 821 1 INV
X820 821 822 1 INV
X821 822 823 1 INV
X822 823 824 1 INV
X823 824 825 1 INV
X824 825 826 1 INV
X825 826 827 1 INV
X826 827 828 1 INV
X827 828 829 1 INV
X828 829 830 1 INV
X829 830 831 1 INV
X830 831 832 1 INV
X831 832 833 1 INV
X832 833 834 1 INV
X833 834 835 1 INV
X834 835 836 1 INV
X835 836 837 1 INV
X836 837 838 1 INV
X837 838 839 1 INV
X838 839 840 1 INV
X839 840 841 1 INV
X840 841 842 1 INV
X841 842 843 1 INV
X842 843 844 1 INV
X843 844 845 1 INV
X844 845 846 1 INV
X845 846 847 1 INV
X846 847 848 1 INV
X847 848 849 1 INV
X848 849 850 1 INV
X849 850 851 1 INV
X850 851 852 1 INV
X851 852 853 1 INV
X852 853 854 1 INV
X853 854 855 1 INV
X854 855 856 1 INV
X855 856 857 1 INV
X856 857 858 1 INV
X857 858 859 1 INV
X858 859 860 1 INV
X859 860 861 1 INV
X860 861 862 1 INV
X861 862 863 1 INV
X862 863 864 1 INV
X863 864 865 1 INV
X864 865 866 1 INV
X865 866 867 1 INV
X866 867 868 1 INV
X867 868 869 1 INV
X868 869 870 1 INV
X869 870 871 1 INV
X870 871 872 1 INV
X871 872 873 1 INV
X872 873 874 1 INV
X873 874 875 1 INV
X874 875 876 1 INV
X875 876 877 1 INV
X876 877 878 1 INV
X877 878 879 1 INV
X878 879 880 1 INV
X879 880 881 1 INV
X880 881 882 1 INV
X881 882 883 1 INV
X882 883 884 1 INV
X883 884 885 1 INV
X884 885 886 1 INV
X885 886 887 1 INV
X886 887 888 1 INV
X887 888 889 1 INV
X888 889 890 1 INV
X889 890 891 1 INV
X890 891 892 1 INV
X891 892 893 1 INV
X892 893 894 1 INV
X893 894 895 1 INV
X894 895 896 1 INV
X895 896 897 1 INV
X896 897 898 1 INV
X897 898 899 1 INV
X898 899 900 1 INV
X899 900 901 1 INV
X900 901 902 1 INV
X901 902 903 1 INV
X902 903 904 1 INV
X903 904 905 1 INV
X904 905 906 1 INV
X905 906 907 1 INV
X906 907 908 1 INV
X907 908 909 1 INV
X908 909 910 1 INV
X909 910 911 1 INV
X910 911 912 1 INV
X911 912 913 1 INV
X912 913 914 1 INV
X913 914 915 1 INV
X914 915 916 1 INV
X915 916 917 1 INV
X916 917 918 1 INV
X917 918 919 1 INV
X918 919 920 1 INV
X919 920 921 1 INV
X920 921 922 1 INV
X921 922 923 1 INV
X922 923 924 1 INV
X923 924 925 1 INV
X924 925 926 1 INV
X925 926 927 1 INV
X926 927 928 1 INV
X927 928 929 1 INV
X928 929 930 1 INV
X929 930 931 1 INV
X930 931 932 1 INV
X931 932 933 1 INV
X932 933 934 1 INV
X933 934 935 1 INV
X934 935 936 1 INV
X935 936 937 1 INV
X936 937 938 1 INV
X937 938 939 1 INV
X938 939 940 1 INV
X939 940 941 1 INV
X940 941 942 1 INV
X941 942 943 1 INV
X942 943 944 1 INV
X943 944 945 1 INV
X944 945 946 1 INV
X945 946 947 1 INV
X946 947 948 1 INV
X947 948 949 1 INV
X948 949 950 1 INV
X949 950 951 1 INV
X950 951 952 1 INV
X951 952 953 1 INV
X952 953 954 1 INV
X953 954 955 1 INV
X954 955 956 1 INV
X955 956 957 1 INV
X956 957 958 1 INV
X957 958 959 1 INV
X958 959 960 1 INV
X959 960 961 1 INV
X960 961 962 1 INV
X961 962 963 1 INV
X962 963 964 1 INV
X963 964 965 1 INV
X964 965 966 1 INV
X965 966 967 1 INV
X966 967 968 1 INV
X967 968 969 1 INV
X968 969 970 1 INV
X969 970 971 1 INV
X970 971 972 1 INV
X971 972 973 1 INV
X972 973 974 1 INV
X973 974 975 1 INV
X974 975 976 1 INV
X975 976 977 1 INV
X976 977 978 1 INV
X977 978 979 1 INV
X978 979 980 1 INV
X979 980 981 1 INV
X980 981 982 1 INV
X981 982 983 1 INV
X982 983 984 1 INV
X983 984 985 1 INV
X984 985 986 1 INV
X985 986 987 1 INV
X986 987 988 1 INV
X987 988 989 1 INV
X988 989 990 1 INV
X989 990 991 1 INV
X990 991 992 1 INV
X991 992 993 1 INV
X992 993 994 1 INV
X993 994 995 1 INV
X994 995 996 1 INV
X995 996 997 1 INV
X996 997 998 1 INV
X997 998 999 1 INV
X998 999 1000 1 INV
X999 1000 1001 1 INV
X1000 1001 1002 1 INV
.subckt INV a y vdd
MP y a vdd vdd PM W=20u L=1u
MN y a 0 0 NM W=10u L=1u
.ends
.model NM NMOS(VTO=0.7 KP=60u LAMBDA=0.02 CJ=3e-4 CJSW=3e-10 CGSO=3e-10 CGDO=3e-10 TOX=20n)
.model PM PMOS(VTO=-0.9 KP=25u LAMBDA=0.02 CJ=3e-4 CJSW=3e-10 CGSO=3e-10 CGDO=3e-10 TOX=20n)
.op
.end
