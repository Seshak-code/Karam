* XSPICE Reference 2: DFF 2-bit Ripple Counter clocked through adc_bridge
vclk clk_a 0 pulse(0 3 1n 0.1n 0.1n 1n 2n)
a_adc [clk_a] [clk_d] adc_mod
.model adc_mod adc_bridge(in_low=1.0 in_high=2.0)

* DFF0: D=q0_b, CLK=clk_d, SET=NULL, RESET=NULL, OUT=q0, NOUT=q0_b
a_dff0 q0_b clk_d NULL NULL q0 q0_b dff_mod
.model dff_mod d_dff(clk_delay=0.2n ic=0)

* DFF1: D=q1_b, CLK=q0_b, SET=NULL, RESET=NULL, OUT=q1, NOUT=q1_b
a_dff1 q1_b q0_b NULL NULL q1 q1_b dff_mod

a_dac0 [q0] [v_q0] dac_mod
a_dac1 [q1] [v_q1] dac_mod
.model dac_mod dac_bridge(out_low=0 out_high=3.3 t_rise=0.1n t_fall=0.1n)

.tran 0.1n 10n
.control
run
print v(clk_a) v(v_q0) v(v_q1)
eprint clk_d q0 q1
.endc
.end
