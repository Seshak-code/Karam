* rtl chain qa2_ss_tran60.cir: source stepping then analysis
.options gminsteps=0
VCC 1 0 DC 5
VIN 2 0 PULSE(0 5 2n 1n 1n 10n 40n)
RB0 2 b0 10k
Q0 3 b0 0 NP
RC0 1 3 1k
RB1 3 b1 10k
Q1 4 b1 0 NP
RC1 1 4 1k
RB2 4 b2 10k
Q2 5 b2 0 NP
RC2 1 5 1k
RB3 5 b3 10k
Q3 6 b3 0 NP
RC3 1 6 1k
RB4 6 b4 10k
Q4 7 b4 0 NP
RC4 1 7 1k
RB5 7 b5 10k
Q5 8 b5 0 NP
RC5 1 8 1k
RB6 8 b6 10k
Q6 9 b6 0 NP
RC6 1 9 1k
RB7 9 b7 10k
Q7 10 b7 0 NP
RC7 1 10 1k
RB8 10 b8 10k
Q8 11 b8 0 NP
RC8 1 11 1k
RB9 11 b9 10k
Q9 12 b9 0 NP
RC9 1 12 1k
RB10 12 b10 10k
Q10 13 b10 0 NP
RC10 1 13 1k
RB11 13 b11 10k
Q11 14 b11 0 NP
RC11 1 14 1k
RB12 14 b12 10k
Q12 15 b12 0 NP
RC12 1 15 1k
RB13 15 b13 10k
Q13 16 b13 0 NP
RC13 1 16 1k
RB14 16 b14 10k
Q14 17 b14 0 NP
RC14 1 17 1k
RB15 17 b15 10k
Q15 18 b15 0 NP
RC15 1 18 1k
RB16 18 b16 10k
Q16 19 b16 0 NP
RC16 1 19 1k
RB17 19 b17 10k
Q17 20 b17 0 NP
RC17 1 20 1k
RB18 20 b18 10k
Q18 21 b18 0 NP
RC18 1 21 1k
RB19 21 b19 10k
Q19 22 b19 0 NP
RC19 1 22 1k
RB20 22 b20 10k
Q20 23 b20 0 NP
RC20 1 23 1k
RB21 23 b21 10k
Q21 24 b21 0 NP
RC21 1 24 1k
RB22 24 b22 10k
Q22 25 b22 0 NP
RC22 1 25 1k
RB23 25 b23 10k
Q23 26 b23 0 NP
RC23 1 26 1k
RB24 26 b24 10k
Q24 27 b24 0 NP
RC24 1 27 1k
RB25 27 b25 10k
Q25 28 b25 0 NP
RC25 1 28 1k
RB26 28 b26 10k
Q26 29 b26 0 NP
RC26 1 29 1k
RB27 29 b27 10k
Q27 30 b27 0 NP
RC27 1 30 1k
RB28 30 b28 10k
Q28 31 b28 0 NP
RC28 1 31 1k
RB29 31 b29 10k
Q29 32 b29 0 NP
RC29 1 32 1k
RB30 32 b30 10k
Q30 33 b30 0 NP
RC30 1 33 1k
RB31 33 b31 10k
Q31 34 b31 0 NP
RC31 1 34 1k
RB32 34 b32 10k
Q32 35 b32 0 NP
RC32 1 35 1k
RB33 35 b33 10k
Q33 36 b33 0 NP
RC33 1 36 1k
RB34 36 b34 10k
Q34 37 b34 0 NP
RC34 1 37 1k
RB35 37 b35 10k
Q35 38 b35 0 NP
RC35 1 38 1k
RB36 38 b36 10k
Q36 39 b36 0 NP
RC36 1 39 1k
RB37 39 b37 10k
Q37 40 b37 0 NP
RC37 1 40 1k
RB38 40 b38 10k
Q38 41 b38 0 NP
RC38 1 41 1k
RB39 41 b39 10k
Q39 42 b39 0 NP
RC39 1 42 1k
RB40 42 b40 10k
Q40 43 b40 0 NP
RC40 1 43 1k
RB41 43 b41 10k
Q41 44 b41 0 NP
RC41 1 44 1k
RB42 44 b42 10k
Q42 45 b42 0 NP
RC42 1 45 1k
RB43 45 b43 10k
Q43 46 b43 0 NP
RC43 1 46 1k
RB44 46 b44 10k
Q44 47 b44 0 NP
RC44 1 47 1k
RB45 47 b45 10k
Q45 48 b45 0 NP
RC45 1 48 1k
RB46 48 b46 10k
Q46 49 b46 0 NP
RC46 1 49 1k
RB47 49 b47 10k
Q47 50 b47 0 NP
RC47 1 50 1k
RB48 50 b48 10k
Q48 51 b48 0 NP
RC48 1 51 1k
RB49 51 b49 10k
Q49 52 b49 0 NP
RC49 1 52 1k
RB50 52 b50 10k
Q50 53 b50 0 NP
RC50 1 53 1k
RB51 53 b51 10k
Q51 54 b51 0 NP
RC51 1 54 1k
RB52 54 b52 10k
Q52 55 b52 0 NP
RC52 1 55 1k
RB53 55 b53 10k
Q53 56 b53 0 NP
RC53 1 56 1k
RB54 56 b54 10k
Q54 57 b54 0 NP
RC54 1 57 1k
RB55 57 b55 10k
Q55 58 b55 0 NP
RC55 1 58 1k
RB56 58 b56 10k
Q56 59 b56 0 NP
RC56 1 59 1k
RB57 59 b57 10k
Q57 60 b57 0 NP
RC57 1 60 1k
RB58 60 b58 10k
Q58 61 b58 0 NP
RC58 1 61 1k
RB59 61 b59 10k
Q59 62 b59 0 NP
RC59 1 62 1k
.model NP NPN(IS=1e-15 BF=100 CJE=1p CJC=1p TF=0.1n)
.tran 0.2n 30n
.end
