* qa3: IHP hv nmos, default geometry (w=0.35u l=0.34u)
.osdi psp103.osdi
.lib pdk/ihp/ihp-sg13g2/libs.tech/ngspice/models/cornerMOShv.lib mos_tt
VDD 1 0 DC 3.3
VG 2 0 DC 0
RD 1 3 10k
XN 3 2 0 0 sg13_hv_nmos
.dc VG 0 3.3 0.15
.end
