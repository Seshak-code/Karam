* Diode breakdown: BV/IBV knee (zener regulator) and an IBV below the knee current
V1 1 0 DC 0
R1 1 2 1k
D1 0 2 DZ
R2 1 3 10k
D2 0 3 DZK
.model DZ D(IS=1e-14 BV=5.1 IBV=5m)
.model DZK D(IS=1e-12 N=1.2 BV=12 IBV=1e-10)
.dc V1 0 20 0.1
.end
