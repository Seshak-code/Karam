* qa4: PWL step transition on R= repeat timestamp
V1 1 0 PWL(0 0 1n 1 1n 0 2n 0 R 1n)
R1 1 0 1k
.tran 0.1n 3n
.end
