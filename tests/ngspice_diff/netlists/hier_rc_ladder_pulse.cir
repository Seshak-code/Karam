hier RC ladder PULSE transient
V1 1 0 PULSE(0 5 0 1u 1u 1m 2m)
X1 1 2 RC
X2 2 3 RC
X3 3 4 RC
.subckt RC in out
R1 in out 1k
C1 out 0 100n
.ends
.tran 10u 2m
.end
