* sky130 (real PDK): nfet_01v8 through the PDK's subcircuit, native BSIM4 card (level 54, binned),
* .option scale=1u from the library; the engine runs it on the OSDI BSIM4
.lib lib/sky130_tt_min.lib tt
VDD 1 0 DC 1.8
VG 2 0 DC 0
RD 1 3 5k
XN 3 2 0 0 sky130_fd_pr__nfet_01v8 l=0.15 w=1
.dc VG 0 1.8 0.1
.end
