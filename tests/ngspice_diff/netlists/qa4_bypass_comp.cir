* qa4: CMOS inverter comparator near threshold under slow ramp
.lib lib/sky130_tt_min.lib tt
VDD vdd 0 DC 1.8
* Slow ramp crossing switching threshold (~0.9V)
VIN in 0 PWL(0 0.85 100n 0.95)
XP out in vdd vdd sky130_fd_pr__pfet_01v8_hvt l=0.15 w=1.0
XN out in 0 0 sky130_fd_pr__nfet_01v8 l=0.15 w=0.65
CL out 0 10f
.tran 0.5n 100n
.end
