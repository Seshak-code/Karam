* OSDI: BSIM4 (OpenVAF) NMOS with a drain resistor, gate swept through threshold
.osdi bsim4.osdi
VDD 1 0 DC 1.2
VG 2 0 DC 0
RD 1 3 5k
N1 3 2 0 0 nch
.model nch bsim4va type=1 w=1u l=100n
.dc VG 0 1.2 0.05
.end
