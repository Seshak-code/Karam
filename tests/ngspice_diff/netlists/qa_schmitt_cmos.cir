* QA: 6-transistor CMOS Schmitt trigger, DC sweep up (hysteresis, branch-following)
VDD 1 0 DC 3.3
VIN 2 0 DC 0
MP1 3 2 1 1 PM W=10u L=1u
MP2 4 2 3 1 PM W=10u L=1u
MP3 0 4 3 1 PM W=10u L=1u
MN1 5 2 0 0 NM W=5u L=1u
MN2 4 2 5 0 NM W=5u L=1u
MN3 1 4 5 0 NM W=5u L=1u
.model NM NMOS(VTO=0.7 KP=60u LAMBDA=0.02 GAMMA=0.4 PHI=0.7)
.model PM PMOS(VTO=-0.8 KP=25u LAMBDA=0.02 GAMMA=0.4 PHI=0.7)
.dc VIN 0 3.3 0.05
.end
