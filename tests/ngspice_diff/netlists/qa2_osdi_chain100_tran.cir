* chain
.osdi bsim4.osdi
VDD 1 0 DC 1.2
VIN 2 0 PULSE(0 1.2 0.2n 50p 50p 1n 2.4n)
NP0 o0 2 1 1 pch
NN0 o0 2 0 0 nch
NP1 o1 o0 1 1 pch
NN1 o1 o0 0 0 nch
NP2 o2 o1 1 1 pch
NN2 o2 o1 0 0 nch
NP3 o3 o2 1 1 pch
NN3 o3 o2 0 0 nch
NP4 o4 o3 1 1 pch
NN4 o4 o3 0 0 nch
NP5 o5 o4 1 1 pch
NN5 o5 o4 0 0 nch
NP6 o6 o5 1 1 pch
NN6 o6 o5 0 0 nch
NP7 o7 o6 1 1 pch
NN7 o7 o6 0 0 nch
NP8 o8 o7 1 1 pch
NN8 o8 o7 0 0 nch
NP9 o9 o8 1 1 pch
NN9 o9 o8 0 0 nch
NP10 o10 o9 1 1 pch
NN10 o10 o9 0 0 nch
NP11 o11 o10 1 1 pch
NN11 o11 o10 0 0 nch
NP12 o12 o11 1 1 pch
NN12 o12 o11 0 0 nch
NP13 o13 o12 1 1 pch
NN13 o13 o12 0 0 nch
NP14 o14 o13 1 1 pch
NN14 o14 o13 0 0 nch
NP15 o15 o14 1 1 pch
NN15 o15 o14 0 0 nch
NP16 o16 o15 1 1 pch
NN16 o16 o15 0 0 nch
NP17 o17 o16 1 1 pch
NN17 o17 o16 0 0 nch
NP18 o18 o17 1 1 pch
NN18 o18 o17 0 0 nch
NP19 o19 o18 1 1 pch
NN19 o19 o18 0 0 nch
NP20 o20 o19 1 1 pch
NN20 o20 o19 0 0 nch
NP21 o21 o20 1 1 pch
NN21 o21 o20 0 0 nch
NP22 o22 o21 1 1 pch
NN22 o22 o21 0 0 nch
NP23 o23 o22 1 1 pch
NN23 o23 o22 0 0 nch
NP24 o24 o23 1 1 pch
NN24 o24 o23 0 0 nch
NP25 o25 o24 1 1 pch
NN25 o25 o24 0 0 nch
NP26 o26 o25 1 1 pch
NN26 o26 o25 0 0 nch
NP27 o27 o26 1 1 pch
NN27 o27 o26 0 0 nch
NP28 o28 o27 1 1 pch
NN28 o28 o27 0 0 nch
NP29 o29 o28 1 1 pch
NN29 o29 o28 0 0 nch
NP30 o30 o29 1 1 pch
NN30 o30 o29 0 0 nch
NP31 o31 o30 1 1 pch
NN31 o31 o30 0 0 nch
NP32 o32 o31 1 1 pch
NN32 o32 o31 0 0 nch
NP33 o33 o32 1 1 pch
NN33 o33 o32 0 0 nch
NP34 o34 o33 1 1 pch
NN34 o34 o33 0 0 nch
NP35 o35 o34 1 1 pch
NN35 o35 o34 0 0 nch
NP36 o36 o35 1 1 pch
NN36 o36 o35 0 0 nch
NP37 o37 o36 1 1 pch
NN37 o37 o36 0 0 nch
NP38 o38 o37 1 1 pch
NN38 o38 o37 0 0 nch
NP39 o39 o38 1 1 pch
NN39 o39 o38 0 0 nch
NP40 o40 o39 1 1 pch
NN40 o40 o39 0 0 nch
NP41 o41 o40 1 1 pch
NN41 o41 o40 0 0 nch
NP42 o42 o41 1 1 pch
NN42 o42 o41 0 0 nch
NP43 o43 o42 1 1 pch
NN43 o43 o42 0 0 nch
NP44 o44 o43 1 1 pch
NN44 o44 o43 0 0 nch
NP45 o45 o44 1 1 pch
NN45 o45 o44 0 0 nch
NP46 o46 o45 1 1 pch
NN46 o46 o45 0 0 nch
NP47 o47 o46 1 1 pch
NN47 o47 o46 0 0 nch
NP48 o48 o47 1 1 pch
NN48 o48 o47 0 0 nch
NP49 o49 o48 1 1 pch
NN49 o49 o48 0 0 nch
NP50 o50 o49 1 1 pch
NN50 o50 o49 0 0 nch
NP51 o51 o50 1 1 pch
NN51 o51 o50 0 0 nch
NP52 o52 o51 1 1 pch
NN52 o52 o51 0 0 nch
NP53 o53 o52 1 1 pch
NN53 o53 o52 0 0 nch
NP54 o54 o53 1 1 pch
NN54 o54 o53 0 0 nch
NP55 o55 o54 1 1 pch
NN55 o55 o54 0 0 nch
NP56 o56 o55 1 1 pch
NN56 o56 o55 0 0 nch
NP57 o57 o56 1 1 pch
NN57 o57 o56 0 0 nch
NP58 o58 o57 1 1 pch
NN58 o58 o57 0 0 nch
NP59 o59 o58 1 1 pch
NN59 o59 o58 0 0 nch
NP60 o60 o59 1 1 pch
NN60 o60 o59 0 0 nch
NP61 o61 o60 1 1 pch
NN61 o61 o60 0 0 nch
NP62 o62 o61 1 1 pch
NN62 o62 o61 0 0 nch
NP63 o63 o62 1 1 pch
NN63 o63 o62 0 0 nch
NP64 o64 o63 1 1 pch
NN64 o64 o63 0 0 nch
NP65 o65 o64 1 1 pch
NN65 o65 o64 0 0 nch
NP66 o66 o65 1 1 pch
NN66 o66 o65 0 0 nch
NP67 o67 o66 1 1 pch
NN67 o67 o66 0 0 nch
NP68 o68 o67 1 1 pch
NN68 o68 o67 0 0 nch
NP69 o69 o68 1 1 pch
NN69 o69 o68 0 0 nch
NP70 o70 o69 1 1 pch
NN70 o70 o69 0 0 nch
NP71 o71 o70 1 1 pch
NN71 o71 o70 0 0 nch
NP72 o72 o71 1 1 pch
NN72 o72 o71 0 0 nch
NP73 o73 o72 1 1 pch
NN73 o73 o72 0 0 nch
NP74 o74 o73 1 1 pch
NN74 o74 o73 0 0 nch
NP75 o75 o74 1 1 pch
NN75 o75 o74 0 0 nch
NP76 o76 o75 1 1 pch
NN76 o76 o75 0 0 nch
NP77 o77 o76 1 1 pch
NN77 o77 o76 0 0 nch
NP78 o78 o77 1 1 pch
NN78 o78 o77 0 0 nch
NP79 o79 o78 1 1 pch
NN79 o79 o78 0 0 nch
NP80 o80 o79 1 1 pch
NN80 o80 o79 0 0 nch
NP81 o81 o80 1 1 pch
NN81 o81 o80 0 0 nch
NP82 o82 o81 1 1 pch
NN82 o82 o81 0 0 nch
NP83 o83 o82 1 1 pch
NN83 o83 o82 0 0 nch
NP84 o84 o83 1 1 pch
NN84 o84 o83 0 0 nch
NP85 o85 o84 1 1 pch
NN85 o85 o84 0 0 nch
NP86 o86 o85 1 1 pch
NN86 o86 o85 0 0 nch
NP87 o87 o86 1 1 pch
NN87 o87 o86 0 0 nch
NP88 o88 o87 1 1 pch
NN88 o88 o87 0 0 nch
NP89 o89 o88 1 1 pch
NN89 o89 o88 0 0 nch
NP90 o90 o89 1 1 pch
NN90 o90 o89 0 0 nch
NP91 o91 o90 1 1 pch
NN91 o91 o90 0 0 nch
NP92 o92 o91 1 1 pch
NN92 o92 o91 0 0 nch
NP93 o93 o92 1 1 pch
NN93 o93 o92 0 0 nch
NP94 o94 o93 1 1 pch
NN94 o94 o93 0 0 nch
NP95 o95 o94 1 1 pch
NN95 o95 o94 0 0 nch
NP96 o96 o95 1 1 pch
NN96 o96 o95 0 0 nch
NP97 o97 o96 1 1 pch
NN97 o97 o96 0 0 nch
NP98 o98 o97 1 1 pch
NN98 o98 o97 0 0 nch
NP99 o99 o98 1 1 pch
NN99 o99 o98 0 0 nch
.model nch bsim4va type=1 w=1u l=100n
.model pch bsim4va type=-1 w=2u l=100n
.tran 10p 0.8n
.end
