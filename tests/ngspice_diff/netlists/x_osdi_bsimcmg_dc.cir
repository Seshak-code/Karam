* OSDI: BSIM-CMG (OpenVAF) FinFET NMOS, 4 of 5 terminals connected (thermal node left open)
.osdi bsimcmg.osdi
VDD 1 0 DC 0.8
VG 2 0 DC 0
RD 1 3 20k
N1 3 2 0 0 nfin
.model nfin bsimcmg_va type=1
.dc VG 0 0.8 0.05
.end
