* 100-stage CMOS inverter chain .op: plain Newton fails; ngspice converges by dynamic gmin stepping
VDD 1 0 DC 5
VIN 2 0 DC 0
X1 2 3 1 INV
X2 3 4 1 INV
X3 4 5 1 INV
X4 5 6 1 INV
X5 6 7 1 INV
X6 7 8 1 INV
X7 8 9 1 INV
X8 9 10 1 INV
X9 10 11 1 INV
X10 11 12 1 INV
X11 12 13 1 INV
X12 13 14 1 INV
X13 14 15 1 INV
X14 15 16 1 INV
X15 16 17 1 INV
X16 17 18 1 INV
X17 18 19 1 INV
X18 19 20 1 INV
X19 20 21 1 INV
X20 21 22 1 INV
X21 22 23 1 INV
X22 23 24 1 INV
X23 24 25 1 INV
X24 25 26 1 INV
X25 26 27 1 INV
X26 27 28 1 INV
X27 28 29 1 INV
X28 29 30 1 INV
X29 30 31 1 INV
X30 31 32 1 INV
X31 32 33 1 INV
X32 33 34 1 INV
X33 34 35 1 INV
X34 35 36 1 INV
X35 36 37 1 INV
X36 37 38 1 INV
X37 38 39 1 INV
X38 39 40 1 INV
X39 40 41 1 INV
X40 41 42 1 INV
X41 42 43 1 INV
X42 43 44 1 INV
X43 44 45 1 INV
X44 45 46 1 INV
X45 46 47 1 INV
X46 47 48 1 INV
X47 48 49 1 INV
X48 49 50 1 INV
X49 50 51 1 INV
X50 51 52 1 INV
X51 52 53 1 INV
X52 53 54 1 INV
X53 54 55 1 INV
X54 55 56 1 INV
X55 56 57 1 INV
X56 57 58 1 INV
X57 58 59 1 INV
X58 59 60 1 INV
X59 60 61 1 INV
X60 61 62 1 INV
X61 62 63 1 INV
X62 63 64 1 INV
X63 64 65 1 INV
X64 65 66 1 INV
X65 66 67 1 INV
X66 67 68 1 INV
X67 68 69 1 INV
X68 69 70 1 INV
X69 70 71 1 INV
X70 71 72 1 INV
X71 72 73 1 INV
X72 73 74 1 INV
X73 74 75 1 INV
X74 75 76 1 INV
X75 76 77 1 INV
X76 77 78 1 INV
X77 78 79 1 INV
X78 79 80 1 INV
X79 80 81 1 INV
X80 81 82 1 INV
X81 82 83 1 INV
X82 83 84 1 INV
X83 84 85 1 INV
X84 85 86 1 INV
X85 86 87 1 INV
X86 87 88 1 INV
X87 88 89 1 INV
X88 89 90 1 INV
X89 90 91 1 INV
X90 91 92 1 INV
X91 92 93 1 INV
X92 93 94 1 INV
X93 94 95 1 INV
X94 95 96 1 INV
X95 96 97 1 INV
X96 97 98 1 INV
X97 98 99 1 INV
X98 99 100 1 INV
X99 100 101 1 INV
X100 101 102 1 INV
RL 102 0 100k
.subckt INV IN OUT VP
MN OUT IN 0 0 NMI W=10u L=1u
MP OUT IN VP VP PMI W=20u L=1u
.ends INV
.model NMI NMOS(KP=100u VTO=0.7 GAMMA=0.4 PHI=0.6)
.model PMI PMOS(KP=50u VTO=-0.8 GAMMA=0.4 PHI=0.6)
.op
.end
