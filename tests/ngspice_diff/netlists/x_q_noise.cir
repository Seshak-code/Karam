* BJT noise: collector and base shot noise (internal nodes) + RB/RC/RE thermal noise
VCC 1 0 DC 9
VIN 5 0 DC 0.8 AC 1
RS 5 2 1k
RC 1 3 5k
Q1 3 2 0 QN
.model QN NPN(IS=1e-15 BF=150 VAF=50 RB=300 RC=20 RE=2 CJE=1p CJC=0.5p)
.noise V(3) VIN DEC 10 10 100MEG
.end
