* QA: high-current switching with TF/XTF/VTF/ITF (bias-dependent transit time), CJE/CJC/CJS, tran
VCC 1 0 DC 5
VIN 6 0 PULSE(0 3 5n 1n 1n 60n 150n)
RB 6 2 200
Q1 3 2 0 0 QX
RC 1 3 100
.model QX NPN(IS=1e-15 BF=120 BR=2 TF=0.5n XTF=4 VTF=2 ITF=20m TR=8n CJE=2p CJC=1p CJS=1p VJC=0.6 MJC=0.4 RB=50 RC=5 RE=2 IKF=50m)
.tran 0.2n 150n
.end
