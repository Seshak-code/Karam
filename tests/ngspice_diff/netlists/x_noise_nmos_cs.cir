* noise: NMOS common-source stage (channel thermal 8kTgm/3)
VDD 1 0 DC 5
VG 2 0 DC 1.2 AC 1
RD 1 3 10k
M1 3 2 0 0 NM W=10u L=1u
.model NM NMOS(LEVEL=1 KP=100u VTO=0.7 LAMBDA=0.02)
.noise v(3) VG dec 3 10 10meg
.end
