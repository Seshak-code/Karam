* qa3: binned BSIM4 (level 54) family, global NAME.0..N: bin edges. Each bin has a distinct vth0
.model nb.0 nmos (level=54 version=4.5 tnom=26.83 vth0=0.40 toxe=4n toxm=4n lmin=0.1u lmax=1u wmin=1u wmax=5u)
.model nb.1 nmos (level=54 version=4.5 tnom=26.83 vth0=0.45 toxe=4n toxm=4n lmin=0.1u lmax=1u wmin=5u wmax=20u)
.model nb.2 nmos (level=54 version=4.5 tnom=26.83 vth0=0.50 toxe=4n toxm=4n lmin=1u lmax=10u wmin=1u wmax=5u)
.model nb.3 nmos (level=54 version=4.5 tnom=26.83 vth0=0.55 toxe=4n toxm=4n lmin=1u lmax=10u wmin=5u wmax=20u)
V1 1 0 DC 2
VG 2 0 DC 1.2
M1 3 2 0 0 nb W=1u L=0.1u
M2 4 2 0 0 nb W=5u L=0.5u
M3 5 2 0 0 nb W=4.9u L=1.5u
M4 6 2 0 0 nb W=5u L=1u
M5 7 2 0 0 nb W=19u L=9.9u
M6 8 2 0 0 nb W=1u L=9.5u
R1 1 3 2k
R2 1 4 2k
R3 1 5 2k
R4 1 6 2k
R5 1 7 2k
R6 1 8 2k
.op
.end
