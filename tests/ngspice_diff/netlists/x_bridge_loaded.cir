fullwave bridge rectifier with load across the output (aac_10 plus rout)
v1 1 0 sin(0 15 60 0 0)
rload 1 0 10k
rout 2 3 10k
d1 1 2 mod1
d2 0 2 mod1
d3 3 1 mod1
d4 3 0 mod1
.model mod1 d
.tran .5m 25m
.end
