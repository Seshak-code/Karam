* qa3 BUG: sky130 pfet_01v8 W=0.42 (exactly the lowest bin edge): engine "no bin covers", ngspice solves it
.lib lib/sky130_tt_min.lib tt
VDD 1 0 DC 1.8
VG 2 0 DC 0.9
RD 3 0 10k
XP 3 2 1 1 sky130_fd_pr__pfet_01v8 l=0.15 w=0.42
.op
.end
