* OSDI: BSIM4 common-source amplifier noise (model noise sources incl. flicker)
.osdi bsim4.osdi
VDD 1 0 DC 1.2
VIN 4 0 DC 0.5 AC 1
RS 4 2 1k
RD 1 3 10k
N1 3 2 0 0 nch
.model nch bsim4va type=1 w=2u l=100n
.noise v(3) VIN dec 5 10 10g
.end
