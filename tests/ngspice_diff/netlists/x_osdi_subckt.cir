* OSDI inside .subckt instances: BSIM4 inverter chain (per-instance internal nodes)
.osdi bsim4.osdi
.subckt inv in out vdd
NP out in vdd vdd pch
NN out in 0 0 nch
.ends
.model nch bsim4va type=1 w=1u l=100n
.model pch bsim4va type=-1 w=2u l=100n
VDD 1 0 DC 1.2
VIN 2 0 PULSE(0 1.2 0.1n 50p 50p 0.8n 2n)
X1 2 3 1 inv
X2 3 4 1 inv
X3 4 5 1 inv
.tran 5p 2n
.end
