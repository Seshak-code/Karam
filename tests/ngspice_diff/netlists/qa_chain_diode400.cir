* QA: 400-stage diode-clamp ladder .op
V1 1 0 DC 5
R1 1 2 100
D1 2 0 DM
R2 2 3 100
D2 3 0 DM
R3 3 4 100
D3 4 0 DM
R4 4 5 100
D4 5 0 DM
R5 5 6 100
D5 6 0 DM
R6 6 7 100
D6 7 0 DM
R7 7 8 100
D7 8 0 DM
R8 8 9 100
D8 9 0 DM
R9 9 10 100
D9 10 0 DM
R10 10 11 100
D10 11 0 DM
R11 11 12 100
D11 12 0 DM
R12 12 13 100
D12 13 0 DM
R13 13 14 100
D13 14 0 DM
R14 14 15 100
D14 15 0 DM
R15 15 16 100
D15 16 0 DM
R16 16 17 100
D16 17 0 DM
R17 17 18 100
D17 18 0 DM
R18 18 19 100
D18 19 0 DM
R19 19 20 100
D19 20 0 DM
R20 20 21 100
D20 21 0 DM
R21 21 22 100
D21 22 0 DM
R22 22 23 100
D22 23 0 DM
R23 23 24 100
D23 24 0 DM
R24 24 25 100
D24 25 0 DM
R25 25 26 100
D25 26 0 DM
R26 26 27 100
D26 27 0 DM
R27 27 28 100
D27 28 0 DM
R28 28 29 100
D28 29 0 DM
R29 29 30 100
D29 30 0 DM
R30 30 31 100
D30 31 0 DM
R31 31 32 100
D31 32 0 DM
R32 32 33 100
D32 33 0 DM
R33 33 34 100
D33 34 0 DM
R34 34 35 100
D34 35 0 DM
R35 35 36 100
D35 36 0 DM
R36 36 37 100
D36 37 0 DM
R37 37 38 100
D37 38 0 DM
R38 38 39 100
D38 39 0 DM
R39 39 40 100
D39 40 0 DM
R40 40 41 100
D40 41 0 DM
R41 41 42 100
D41 42 0 DM
R42 42 43 100
D42 43 0 DM
R43 43 44 100
D43 44 0 DM
R44 44 45 100
D44 45 0 DM
R45 45 46 100
D45 46 0 DM
R46 46 47 100
D46 47 0 DM
R47 47 48 100
D47 48 0 DM
R48 48 49 100
D48 49 0 DM
R49 49 50 100
D49 50 0 DM
R50 50 51 100
D50 51 0 DM
R51 51 52 100
D51 52 0 DM
R52 52 53 100
D52 53 0 DM
R53 53 54 100
D53 54 0 DM
R54 54 55 100
D54 55 0 DM
R55 55 56 100
D55 56 0 DM
R56 56 57 100
D56 57 0 DM
R57 57 58 100
D57 58 0 DM
R58 58 59 100
D58 59 0 DM
R59 59 60 100
D59 60 0 DM
R60 60 61 100
D60 61 0 DM
R61 61 62 100
D61 62 0 DM
R62 62 63 100
D62 63 0 DM
R63 63 64 100
D63 64 0 DM
R64 64 65 100
D64 65 0 DM
R65 65 66 100
D65 66 0 DM
R66 66 67 100
D66 67 0 DM
R67 67 68 100
D67 68 0 DM
R68 68 69 100
D68 69 0 DM
R69 69 70 100
D69 70 0 DM
R70 70 71 100
D70 71 0 DM
R71 71 72 100
D71 72 0 DM
R72 72 73 100
D72 73 0 DM
R73 73 74 100
D73 74 0 DM
R74 74 75 100
D74 75 0 DM
R75 75 76 100
D75 76 0 DM
R76 76 77 100
D76 77 0 DM
R77 77 78 100
D77 78 0 DM
R78 78 79 100
D78 79 0 DM
R79 79 80 100
D79 80 0 DM
R80 80 81 100
D80 81 0 DM
R81 81 82 100
D81 82 0 DM
R82 82 83 100
D82 83 0 DM
R83 83 84 100
D83 84 0 DM
R84 84 85 100
D84 85 0 DM
R85 85 86 100
D85 86 0 DM
R86 86 87 100
D86 87 0 DM
R87 87 88 100
D87 88 0 DM
R88 88 89 100
D88 89 0 DM
R89 89 90 100
D89 90 0 DM
R90 90 91 100
D90 91 0 DM
R91 91 92 100
D91 92 0 DM
R92 92 93 100
D92 93 0 DM
R93 93 94 100
D93 94 0 DM
R94 94 95 100
D94 95 0 DM
R95 95 96 100
D95 96 0 DM
R96 96 97 100
D96 97 0 DM
R97 97 98 100
D97 98 0 DM
R98 98 99 100
D98 99 0 DM
R99 99 100 100
D99 100 0 DM
R100 100 101 100
D100 101 0 DM
R101 101 102 100
D101 102 0 DM
R102 102 103 100
D102 103 0 DM
R103 103 104 100
D103 104 0 DM
R104 104 105 100
D104 105 0 DM
R105 105 106 100
D105 106 0 DM
R106 106 107 100
D106 107 0 DM
R107 107 108 100
D107 108 0 DM
R108 108 109 100
D108 109 0 DM
R109 109 110 100
D109 110 0 DM
R110 110 111 100
D110 111 0 DM
R111 111 112 100
D111 112 0 DM
R112 112 113 100
D112 113 0 DM
R113 113 114 100
D113 114 0 DM
R114 114 115 100
D114 115 0 DM
R115 115 116 100
D115 116 0 DM
R116 116 117 100
D116 117 0 DM
R117 117 118 100
D117 118 0 DM
R118 118 119 100
D118 119 0 DM
R119 119 120 100
D119 120 0 DM
R120 120 121 100
D120 121 0 DM
R121 121 122 100
D121 122 0 DM
R122 122 123 100
D122 123 0 DM
R123 123 124 100
D123 124 0 DM
R124 124 125 100
D124 125 0 DM
R125 125 126 100
D125 126 0 DM
R126 126 127 100
D126 127 0 DM
R127 127 128 100
D127 128 0 DM
R128 128 129 100
D128 129 0 DM
R129 129 130 100
D129 130 0 DM
R130 130 131 100
D130 131 0 DM
R131 131 132 100
D131 132 0 DM
R132 132 133 100
D132 133 0 DM
R133 133 134 100
D133 134 0 DM
R134 134 135 100
D134 135 0 DM
R135 135 136 100
D135 136 0 DM
R136 136 137 100
D136 137 0 DM
R137 137 138 100
D137 138 0 DM
R138 138 139 100
D138 139 0 DM
R139 139 140 100
D139 140 0 DM
R140 140 141 100
D140 141 0 DM
R141 141 142 100
D141 142 0 DM
R142 142 143 100
D142 143 0 DM
R143 143 144 100
D143 144 0 DM
R144 144 145 100
D144 145 0 DM
R145 145 146 100
D145 146 0 DM
R146 146 147 100
D146 147 0 DM
R147 147 148 100
D147 148 0 DM
R148 148 149 100
D148 149 0 DM
R149 149 150 100
D149 150 0 DM
R150 150 151 100
D150 151 0 DM
R151 151 152 100
D151 152 0 DM
R152 152 153 100
D152 153 0 DM
R153 153 154 100
D153 154 0 DM
R154 154 155 100
D154 155 0 DM
R155 155 156 100
D155 156 0 DM
R156 156 157 100
D156 157 0 DM
R157 157 158 100
D157 158 0 DM
R158 158 159 100
D158 159 0 DM
R159 159 160 100
D159 160 0 DM
R160 160 161 100
D160 161 0 DM
R161 161 162 100
D161 162 0 DM
R162 162 163 100
D162 163 0 DM
R163 163 164 100
D163 164 0 DM
R164 164 165 100
D164 165 0 DM
R165 165 166 100
D165 166 0 DM
R166 166 167 100
D166 167 0 DM
R167 167 168 100
D167 168 0 DM
R168 168 169 100
D168 169 0 DM
R169 169 170 100
D169 170 0 DM
R170 170 171 100
D170 171 0 DM
R171 171 172 100
D171 172 0 DM
R172 172 173 100
D172 173 0 DM
R173 173 174 100
D173 174 0 DM
R174 174 175 100
D174 175 0 DM
R175 175 176 100
D175 176 0 DM
R176 176 177 100
D176 177 0 DM
R177 177 178 100
D177 178 0 DM
R178 178 179 100
D178 179 0 DM
R179 179 180 100
D179 180 0 DM
R180 180 181 100
D180 181 0 DM
R181 181 182 100
D181 182 0 DM
R182 182 183 100
D182 183 0 DM
R183 183 184 100
D183 184 0 DM
R184 184 185 100
D184 185 0 DM
R185 185 186 100
D185 186 0 DM
R186 186 187 100
D186 187 0 DM
R187 187 188 100
D187 188 0 DM
R188 188 189 100
D188 189 0 DM
R189 189 190 100
D189 190 0 DM
R190 190 191 100
D190 191 0 DM
R191 191 192 100
D191 192 0 DM
R192 192 193 100
D192 193 0 DM
R193 193 194 100
D193 194 0 DM
R194 194 195 100
D194 195 0 DM
R195 195 196 100
D195 196 0 DM
R196 196 197 100
D196 197 0 DM
R197 197 198 100
D197 198 0 DM
R198 198 199 100
D198 199 0 DM
R199 199 200 100
D199 200 0 DM
R200 200 201 100
D200 201 0 DM
R201 201 202 100
D201 202 0 DM
R202 202 203 100
D202 203 0 DM
R203 203 204 100
D203 204 0 DM
R204 204 205 100
D204 205 0 DM
R205 205 206 100
D205 206 0 DM
R206 206 207 100
D206 207 0 DM
R207 207 208 100
D207 208 0 DM
R208 208 209 100
D208 209 0 DM
R209 209 210 100
D209 210 0 DM
R210 210 211 100
D210 211 0 DM
R211 211 212 100
D211 212 0 DM
R212 212 213 100
D212 213 0 DM
R213 213 214 100
D213 214 0 DM
R214 214 215 100
D214 215 0 DM
R215 215 216 100
D215 216 0 DM
R216 216 217 100
D216 217 0 DM
R217 217 218 100
D217 218 0 DM
R218 218 219 100
D218 219 0 DM
R219 219 220 100
D219 220 0 DM
R220 220 221 100
D220 221 0 DM
R221 221 222 100
D221 222 0 DM
R222 222 223 100
D222 223 0 DM
R223 223 224 100
D223 224 0 DM
R224 224 225 100
D224 225 0 DM
R225 225 226 100
D225 226 0 DM
R226 226 227 100
D226 227 0 DM
R227 227 228 100
D227 228 0 DM
R228 228 229 100
D228 229 0 DM
R229 229 230 100
D229 230 0 DM
R230 230 231 100
D230 231 0 DM
R231 231 232 100
D231 232 0 DM
R232 232 233 100
D232 233 0 DM
R233 233 234 100
D233 234 0 DM
R234 234 235 100
D234 235 0 DM
R235 235 236 100
D235 236 0 DM
R236 236 237 100
D236 237 0 DM
R237 237 238 100
D237 238 0 DM
R238 238 239 100
D238 239 0 DM
R239 239 240 100
D239 240 0 DM
R240 240 241 100
D240 241 0 DM
R241 241 242 100
D241 242 0 DM
R242 242 243 100
D242 243 0 DM
R243 243 244 100
D243 244 0 DM
R244 244 245 100
D244 245 0 DM
R245 245 246 100
D245 246 0 DM
R246 246 247 100
D246 247 0 DM
R247 247 248 100
D247 248 0 DM
R248 248 249 100
D248 249 0 DM
R249 249 250 100
D249 250 0 DM
R250 250 251 100
D250 251 0 DM
R251 251 252 100
D251 252 0 DM
R252 252 253 100
D252 253 0 DM
R253 253 254 100
D253 254 0 DM
R254 254 255 100
D254 255 0 DM
R255 255 256 100
D255 256 0 DM
R256 256 257 100
D256 257 0 DM
R257 257 258 100
D257 258 0 DM
R258 258 259 100
D258 259 0 DM
R259 259 260 100
D259 260 0 DM
R260 260 261 100
D260 261 0 DM
R261 261 262 100
D261 262 0 DM
R262 262 263 100
D262 263 0 DM
R263 263 264 100
D263 264 0 DM
R264 264 265 100
D264 265 0 DM
R265 265 266 100
D265 266 0 DM
R266 266 267 100
D266 267 0 DM
R267 267 268 100
D267 268 0 DM
R268 268 269 100
D268 269 0 DM
R269 269 270 100
D269 270 0 DM
R270 270 271 100
D270 271 0 DM
R271 271 272 100
D271 272 0 DM
R272 272 273 100
D272 273 0 DM
R273 273 274 100
D273 274 0 DM
R274 274 275 100
D274 275 0 DM
R275 275 276 100
D275 276 0 DM
R276 276 277 100
D276 277 0 DM
R277 277 278 100
D277 278 0 DM
R278 278 279 100
D278 279 0 DM
R279 279 280 100
D279 280 0 DM
R280 280 281 100
D280 281 0 DM
R281 281 282 100
D281 282 0 DM
R282 282 283 100
D282 283 0 DM
R283 283 284 100
D283 284 0 DM
R284 284 285 100
D284 285 0 DM
R285 285 286 100
D285 286 0 DM
R286 286 287 100
D286 287 0 DM
R287 287 288 100
D287 288 0 DM
R288 288 289 100
D288 289 0 DM
R289 289 290 100
D289 290 0 DM
R290 290 291 100
D290 291 0 DM
R291 291 292 100
D291 292 0 DM
R292 292 293 100
D292 293 0 DM
R293 293 294 100
D293 294 0 DM
R294 294 295 100
D294 295 0 DM
R295 295 296 100
D295 296 0 DM
R296 296 297 100
D296 297 0 DM
R297 297 298 100
D297 298 0 DM
R298 298 299 100
D298 299 0 DM
R299 299 300 100
D299 300 0 DM
R300 300 301 100
D300 301 0 DM
R301 301 302 100
D301 302 0 DM
R302 302 303 100
D302 303 0 DM
R303 303 304 100
D303 304 0 DM
R304 304 305 100
D304 305 0 DM
R305 305 306 100
D305 306 0 DM
R306 306 307 100
D306 307 0 DM
R307 307 308 100
D307 308 0 DM
R308 308 309 100
D308 309 0 DM
R309 309 310 100
D309 310 0 DM
R310 310 311 100
D310 311 0 DM
R311 311 312 100
D311 312 0 DM
R312 312 313 100
D312 313 0 DM
R313 313 314 100
D313 314 0 DM
R314 314 315 100
D314 315 0 DM
R315 315 316 100
D315 316 0 DM
R316 316 317 100
D316 317 0 DM
R317 317 318 100
D317 318 0 DM
R318 318 319 100
D318 319 0 DM
R319 319 320 100
D319 320 0 DM
R320 320 321 100
D320 321 0 DM
R321 321 322 100
D321 322 0 DM
R322 322 323 100
D322 323 0 DM
R323 323 324 100
D323 324 0 DM
R324 324 325 100
D324 325 0 DM
R325 325 326 100
D325 326 0 DM
R326 326 327 100
D326 327 0 DM
R327 327 328 100
D327 328 0 DM
R328 328 329 100
D328 329 0 DM
R329 329 330 100
D329 330 0 DM
R330 330 331 100
D330 331 0 DM
R331 331 332 100
D331 332 0 DM
R332 332 333 100
D332 333 0 DM
R333 333 334 100
D333 334 0 DM
R334 334 335 100
D334 335 0 DM
R335 335 336 100
D335 336 0 DM
R336 336 337 100
D336 337 0 DM
R337 337 338 100
D337 338 0 DM
R338 338 339 100
D338 339 0 DM
R339 339 340 100
D339 340 0 DM
R340 340 341 100
D340 341 0 DM
R341 341 342 100
D341 342 0 DM
R342 342 343 100
D342 343 0 DM
R343 343 344 100
D343 344 0 DM
R344 344 345 100
D344 345 0 DM
R345 345 346 100
D345 346 0 DM
R346 346 347 100
D346 347 0 DM
R347 347 348 100
D347 348 0 DM
R348 348 349 100
D348 349 0 DM
R349 349 350 100
D349 350 0 DM
R350 350 351 100
D350 351 0 DM
R351 351 352 100
D351 352 0 DM
R352 352 353 100
D352 353 0 DM
R353 353 354 100
D353 354 0 DM
R354 354 355 100
D354 355 0 DM
R355 355 356 100
D355 356 0 DM
R356 356 357 100
D356 357 0 DM
R357 357 358 100
D357 358 0 DM
R358 358 359 100
D358 359 0 DM
R359 359 360 100
D359 360 0 DM
R360 360 361 100
D360 361 0 DM
R361 361 362 100
D361 362 0 DM
R362 362 363 100
D362 363 0 DM
R363 363 364 100
D363 364 0 DM
R364 364 365 100
D364 365 0 DM
R365 365 366 100
D365 366 0 DM
R366 366 367 100
D366 367 0 DM
R367 367 368 100
D367 368 0 DM
R368 368 369 100
D368 369 0 DM
R369 369 370 100
D369 370 0 DM
R370 370 371 100
D370 371 0 DM
R371 371 372 100
D371 372 0 DM
R372 372 373 100
D372 373 0 DM
R373 373 374 100
D373 374 0 DM
R374 374 375 100
D374 375 0 DM
R375 375 376 100
D375 376 0 DM
R376 376 377 100
D376 377 0 DM
R377 377 378 100
D377 378 0 DM
R378 378 379 100
D378 379 0 DM
R379 379 380 100
D379 380 0 DM
R380 380 381 100
D380 381 0 DM
R381 381 382 100
D381 382 0 DM
R382 382 383 100
D382 383 0 DM
R383 383 384 100
D383 384 0 DM
R384 384 385 100
D384 385 0 DM
R385 385 386 100
D385 386 0 DM
R386 386 387 100
D386 387 0 DM
R387 387 388 100
D387 388 0 DM
R388 388 389 100
D388 389 0 DM
R389 389 390 100
D389 390 0 DM
R390 390 391 100
D390 391 0 DM
R391 391 392 100
D391 392 0 DM
R392 392 393 100
D392 393 0 DM
R393 393 394 100
D393 394 0 DM
R394 394 395 100
D394 395 0 DM
R395 395 396 100
D395 396 0 DM
R396 396 397 100
D396 397 0 DM
R397 397 398 100
D397 398 0 DM
R398 398 399 100
D398 399 0 DM
R399 399 400 100
D399 400 0 DM
R400 400 401 100
D400 401 0 DM
.model DM D(IS=1e-14 RS=1 BV=20 IBV=1e-6)
.op
.end
