* EKV 2.6 on OSDI (ngspice has no native EKV): NMOS Id-Vds family, card from Xyce EKV26 (LEVEL 260 there)
.osdi ekv.osdi
VG g 0 DC 1
VD d 0 DC 1
N1 d g 0 0 nekv l=0.35u w=0.8u as=1e-12 ad=1e-12 ps=2e-6 pd=2e-6
.model nekv ekv_va (type=1 tnom=27 cox=4.379e-3 xj=22.53n vto=0.5706 tcv=1.194e-3 gamma=0.6707 phi=0.45 kp=232.1e-6
+ bex=-1.828 theta=0 e0=42.216meg ucrit=3.146e6 ucex=0.8 lambda=0.2283 dl=-60.86n dw=-209.7n weta=2.001 leta=0.2646
+ q0=230e-6 lk=0.4e-6 iba=0 ibb=300e6 ibbt=800e-6 ibn=1 rsh=0 hdif=0 avto=0 akp=1e-6)
.dc VD 0 3 0.1 VG 0.5 3 0.5
.end
