NMOS inverter with resistor load, input sweep
VDD 1 0 DC 5
VIN 2 0 DC 0
RD 1 3 10k
M1 3 2 0 0 NM W=10u L=1u
.model NM NMOS(LEVEL=1 VTO=1 KP=50u LAMBDA=0.02)
.dc VIN 0 5 0.5
.end
