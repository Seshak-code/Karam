* .print on a .dc sweep: v(a), v(a,b), i(v1)
V1 in 0 0
R1 in out 1k
R2 out 0 2k
D1 out 0 DM
.model DM D(IS=1e-14)
.dc V1 0 5 1
.print dc v(out) v(in,out) i(v1)
.end
