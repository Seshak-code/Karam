* QA: MOS1 small-signal .ac — gm/gds linearisation at the operating point
VDD 1 0 DC 5
RD 1 3 10k
VIN 2 0 DC 2 AC 1
M1 3 2 0 0 NM W=20u L=1u
.model NM NMOS(KP=100u VTO=0.7 LAMBDA=0.02)
.ac DEC 20 10 1MEG
.end
