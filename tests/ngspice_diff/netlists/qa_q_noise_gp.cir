* noise with RB RE RC
VCC 1 0 DC 12
VIN 6 0 DC 0 AC 1
CIN 6 2 1u
R1 1 2 100k
R2 2 0 22k
RC 1 3 3.3k
Q1 3 2 4 0 QN
RE 4 0 470
.model QN NPN(IS=1e-15 BF=180 RB=200 RC=20 RE=5)
.noise V(3) VIN dec 5 10 1meg
.end
