* noise: resistive divider with RC pole (thermal noise, input-referred)
V1 1 0 DC 0 AC 1
R1 1 2 1k
R2 2 0 1k
C1 2 0 1n
.noise v(2) V1 dec 5 1k 10meg
.end
