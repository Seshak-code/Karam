CCCS (F source): I(Vs) = +1 mA; F drives 2*I(Vs) into node 3, so v(3) = +2 V
V1 1 0 DC 1
R1 1 2 1k
Vs 2 0 0
F1 0 3 Vs 2
R2 3 0 1k
.op
.end
