* bsim4 with d=s (shorted channel)
.osdi bsim4.osdi
VDD 1 0 DC 1.2
VG 2 0 DC 0.8
R1 1 3 1k
N1 3 2 3 0 nch
.model nch bsim4va type=1 w=1u l=100n
.op
.end
