* qa3 BUG: level=54 card without TNOM: engine behaves as TNOM=25, ngspice as 27 (here aligned temp=26.83): 4 mV / 0.26% of Id
.model nb nmos (level=54 version=4.5 vth0=0.45 toxe=4n toxm=4n)
V1 1 0 DC 2
VG 2 0 DC 1.2
M1 3 2 0 0 nb W=8u L=0.5u
R1 1 3 2k
.op
.end
