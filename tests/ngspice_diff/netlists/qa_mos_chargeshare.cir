* QA: charge sharing through NMOS pass gate between two caps, tran (charge conservation / Meyer)
VG 1 0 PULSE(0 3.3 5n 1n 1n 100n 300n)
VA 2 0 PULSE(3.3 3.3 0 1n 1n 1 2)
M0 3 4 2 0 NM W=20u L=1u AD=20p AS=20p PD=10u PS=10u
VGA 4 0 PULSE(0 3.3 2n 1n 1n 8n 300n)
C3 3 0 50f
M1 3 1 5 0 NM W=20u L=1u AD=20p AS=20p PD=10u PS=10u
C5 5 0 200f
R5 5 0 1G
R3 3 0 1G
.model NM NMOS(VTO=0.7 KP=60u GAMMA=0.4 PHI=0.7 TOX=20n CGSO=3e-10 CGDO=3e-10 CGBO=2e-10 CJ=3e-4 CJSW=3e-10)
.tran 0.1n 150n
.end
