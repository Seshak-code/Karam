* bsimcmg at 5 V
.osdi bsimcmg.osdi
VDD 1 0 DC 5
VG 2 0 DC 5
R1 1 3 100
N1 3 2 0 0 nfin
.model nfin bsimcmg_va type=1
.dc VG 0 5 0.5
.end
