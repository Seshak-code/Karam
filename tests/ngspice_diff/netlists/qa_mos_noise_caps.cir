* QA: .noise with the full cap set — device noise plus cap-defined bandwidth
VDD 1 0 DC 5
RD 1 3 10k
VIN 2 0 DC 2 AC 1
M1 3 2 0 0 NM W=20u L=1u
.model NM NMOS(KP=100u VTO=0.7 LAMBDA=0.02 TOX=40n CGSO=2n CGDO=2n CBD=20f CBS=20f)
.noise V(3) VIN DEC 20 10 1MEG
.end
