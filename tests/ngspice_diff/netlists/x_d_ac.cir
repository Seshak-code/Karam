* Diode small-signal: forward-biased diffusion (TT) + reverse-biased depletion capacitance
VB 1 0 DC 0.7 AC 1
R1 1 2 100
D1 2 0 DAC
VR 3 0 DC 5 AC 1
R2 3 4 10k
D2 0 4 DAC
.model DAC D(IS=1e-14 TT=5n CJO=10p VJ=0.8 M=0.33 RS=5)
.ac dec 10 1k 1G
.end
