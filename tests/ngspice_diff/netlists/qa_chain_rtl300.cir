* QA: 300-stage BJT RTL inverter chain .op
VCC 1 0 DC 3.6
VIN 2 0 DC 0.2
X1 2 3 1 RTL
X2 3 4 1 RTL
X3 4 5 1 RTL
X4 5 6 1 RTL
X5 6 7 1 RTL
X6 7 8 1 RTL
X7 8 9 1 RTL
X8 9 10 1 RTL
X9 10 11 1 RTL
X10 11 12 1 RTL
X11 12 13 1 RTL
X12 13 14 1 RTL
X13 14 15 1 RTL
X14 15 16 1 RTL
X15 16 17 1 RTL
X16 17 18 1 RTL
X17 18 19 1 RTL
X18 19 20 1 RTL
X19 20 21 1 RTL
X20 21 22 1 RTL
X21 22 23 1 RTL
X22 23 24 1 RTL
X23 24 25 1 RTL
X24 25 26 1 RTL
X25 26 27 1 RTL
X26 27 28 1 RTL
X27 28 29 1 RTL
X28 29 30 1 RTL
X29 30 31 1 RTL
X30 31 32 1 RTL
X31 32 33 1 RTL
X32 33 34 1 RTL
X33 34 35 1 RTL
X34 35 36 1 RTL
X35 36 37 1 RTL
X36 37 38 1 RTL
X37 38 39 1 RTL
X38 39 40 1 RTL
X39 40 41 1 RTL
X40 41 42 1 RTL
X41 42 43 1 RTL
X42 43 44 1 RTL
X43 44 45 1 RTL
X44 45 46 1 RTL
X45 46 47 1 RTL
X46 47 48 1 RTL
X47 48 49 1 RTL
X48 49 50 1 RTL
X49 50 51 1 RTL
X50 51 52 1 RTL
X51 52 53 1 RTL
X52 53 54 1 RTL
X53 54 55 1 RTL
X54 55 56 1 RTL
X55 56 57 1 RTL
X56 57 58 1 RTL
X57 58 59 1 RTL
X58 59 60 1 RTL
X59 60 61 1 RTL
X60 61 62 1 RTL
X61 62 63 1 RTL
X62 63 64 1 RTL
X63 64 65 1 RTL
X64 65 66 1 RTL
X65 66 67 1 RTL
X66 67 68 1 RTL
X67 68 69 1 RTL
X68 69 70 1 RTL
X69 70 71 1 RTL
X70 71 72 1 RTL
X71 72 73 1 RTL
X72 73 74 1 RTL
X73 74 75 1 RTL
X74 75 76 1 RTL
X75 76 77 1 RTL
X76 77 78 1 RTL
X77 78 79 1 RTL
X78 79 80 1 RTL
X79 80 81 1 RTL
X80 81 82 1 RTL
X81 82 83 1 RTL
X82 83 84 1 RTL
X83 84 85 1 RTL
X84 85 86 1 RTL
X85 86 87 1 RTL
X86 87 88 1 RTL
X87 88 89 1 RTL
X88 89 90 1 RTL
X89 90 91 1 RTL
X90 91 92 1 RTL
X91 92 93 1 RTL
X92 93 94 1 RTL
X93 94 95 1 RTL
X94 95 96 1 RTL
X95 96 97 1 RTL
X96 97 98 1 RTL
X97 98 99 1 RTL
X98 99 100 1 RTL
X99 100 101 1 RTL
X100 101 102 1 RTL
X101 102 103 1 RTL
X102 103 104 1 RTL
X103 104 105 1 RTL
X104 105 106 1 RTL
X105 106 107 1 RTL
X106 107 108 1 RTL
X107 108 109 1 RTL
X108 109 110 1 RTL
X109 110 111 1 RTL
X110 111 112 1 RTL
X111 112 113 1 RTL
X112 113 114 1 RTL
X113 114 115 1 RTL
X114 115 116 1 RTL
X115 116 117 1 RTL
X116 117 118 1 RTL
X117 118 119 1 RTL
X118 119 120 1 RTL
X119 120 121 1 RTL
X120 121 122 1 RTL
X121 122 123 1 RTL
X122 123 124 1 RTL
X123 124 125 1 RTL
X124 125 126 1 RTL
X125 126 127 1 RTL
X126 127 128 1 RTL
X127 128 129 1 RTL
X128 129 130 1 RTL
X129 130 131 1 RTL
X130 131 132 1 RTL
X131 132 133 1 RTL
X132 133 134 1 RTL
X133 134 135 1 RTL
X134 135 136 1 RTL
X135 136 137 1 RTL
X136 137 138 1 RTL
X137 138 139 1 RTL
X138 139 140 1 RTL
X139 140 141 1 RTL
X140 141 142 1 RTL
X141 142 143 1 RTL
X142 143 144 1 RTL
X143 144 145 1 RTL
X144 145 146 1 RTL
X145 146 147 1 RTL
X146 147 148 1 RTL
X147 148 149 1 RTL
X148 149 150 1 RTL
X149 150 151 1 RTL
X150 151 152 1 RTL
X151 152 153 1 RTL
X152 153 154 1 RTL
X153 154 155 1 RTL
X154 155 156 1 RTL
X155 156 157 1 RTL
X156 157 158 1 RTL
X157 158 159 1 RTL
X158 159 160 1 RTL
X159 160 161 1 RTL
X160 161 162 1 RTL
X161 162 163 1 RTL
X162 163 164 1 RTL
X163 164 165 1 RTL
X164 165 166 1 RTL
X165 166 167 1 RTL
X166 167 168 1 RTL
X167 168 169 1 RTL
X168 169 170 1 RTL
X169 170 171 1 RTL
X170 171 172 1 RTL
X171 172 173 1 RTL
X172 173 174 1 RTL
X173 174 175 1 RTL
X174 175 176 1 RTL
X175 176 177 1 RTL
X176 177 178 1 RTL
X177 178 179 1 RTL
X178 179 180 1 RTL
X179 180 181 1 RTL
X180 181 182 1 RTL
X181 182 183 1 RTL
X182 183 184 1 RTL
X183 184 185 1 RTL
X184 185 186 1 RTL
X185 186 187 1 RTL
X186 187 188 1 RTL
X187 188 189 1 RTL
X188 189 190 1 RTL
X189 190 191 1 RTL
X190 191 192 1 RTL
X191 192 193 1 RTL
X192 193 194 1 RTL
X193 194 195 1 RTL
X194 195 196 1 RTL
X195 196 197 1 RTL
X196 197 198 1 RTL
X197 198 199 1 RTL
X198 199 200 1 RTL
X199 200 201 1 RTL
X200 201 202 1 RTL
X201 202 203 1 RTL
X202 203 204 1 RTL
X203 204 205 1 RTL
X204 205 206 1 RTL
X205 206 207 1 RTL
X206 207 208 1 RTL
X207 208 209 1 RTL
X208 209 210 1 RTL
X209 210 211 1 RTL
X210 211 212 1 RTL
X211 212 213 1 RTL
X212 213 214 1 RTL
X213 214 215 1 RTL
X214 215 216 1 RTL
X215 216 217 1 RTL
X216 217 218 1 RTL
X217 218 219 1 RTL
X218 219 220 1 RTL
X219 220 221 1 RTL
X220 221 222 1 RTL
X221 222 223 1 RTL
X222 223 224 1 RTL
X223 224 225 1 RTL
X224 225 226 1 RTL
X225 226 227 1 RTL
X226 227 228 1 RTL
X227 228 229 1 RTL
X228 229 230 1 RTL
X229 230 231 1 RTL
X230 231 232 1 RTL
X231 232 233 1 RTL
X232 233 234 1 RTL
X233 234 235 1 RTL
X234 235 236 1 RTL
X235 236 237 1 RTL
X236 237 238 1 RTL
X237 238 239 1 RTL
X238 239 240 1 RTL
X239 240 241 1 RTL
X240 241 242 1 RTL
X241 242 243 1 RTL
X242 243 244 1 RTL
X243 244 245 1 RTL
X244 245 246 1 RTL
X245 246 247 1 RTL
X246 247 248 1 RTL
X247 248 249 1 RTL
X248 249 250 1 RTL
X249 250 251 1 RTL
X250 251 252 1 RTL
X251 252 253 1 RTL
X252 253 254 1 RTL
X253 254 255 1 RTL
X254 255 256 1 RTL
X255 256 257 1 RTL
X256 257 258 1 RTL
X257 258 259 1 RTL
X258 259 260 1 RTL
X259 260 261 1 RTL
X260 261 262 1 RTL
X261 262 263 1 RTL
X262 263 264 1 RTL
X263 264 265 1 RTL
X264 265 266 1 RTL
X265 266 267 1 RTL
X266 267 268 1 RTL
X267 268 269 1 RTL
X268 269 270 1 RTL
X269 270 271 1 RTL
X270 271 272 1 RTL
X271 272 273 1 RTL
X272 273 274 1 RTL
X273 274 275 1 RTL
X274 275 276 1 RTL
X275 276 277 1 RTL
X276 277 278 1 RTL
X277 278 279 1 RTL
X278 279 280 1 RTL
X279 280 281 1 RTL
X280 281 282 1 RTL
X281 282 283 1 RTL
X282 283 284 1 RTL
X283 284 285 1 RTL
X284 285 286 1 RTL
X285 286 287 1 RTL
X286 287 288 1 RTL
X287 288 289 1 RTL
X288 289 290 1 RTL
X289 290 291 1 RTL
X290 291 292 1 RTL
X291 292 293 1 RTL
X292 293 294 1 RTL
X293 294 295 1 RTL
X294 295 296 1 RTL
X295 296 297 1 RTL
X296 297 298 1 RTL
X297 298 299 1 RTL
X298 299 300 1 RTL
X299 300 301 1 RTL
X300 301 302 1 RTL
.subckt RTL a y vcc
RB a b 2k
Q1 y b 0 QN
RC vcc y 1k
.ends
.model QN NPN(IS=1e-15 BF=50 BR=2 RB=50 RC=10 CJE=1p CJC=1p TF=0.3n)
.op
.end
