* qa4: step last
V1 1 0 PWL(0 0 1n 1 2n 2 2n 0)
R1 1 0 1k
.tran 0.1n 3n
.end
