* qa3: ac with parametrized RLC and .if choosing topology
.param fc = 1meg  q = 5
.param l = {1/(2*3.14159265358979*fc)**2/1n}
.param r = {sqrt(l/1n)/q}
.subckt tank a b params: sel=1
.if (sel == 1)
L1 a b {l}
.else
R1 a b {r}
.endif
.ends
V1 in 0 DC 0 AC 1
R1 in out {r}
X1 out 0 tank
C1 out 0 1n
.ac dec 20 100k 10meg
.end
